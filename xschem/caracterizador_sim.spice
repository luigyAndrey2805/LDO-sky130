** sch_path: /foss/designs/LDO-sky130/xschem/caracterizador.sch
**.subckt caracterizador
Vgp VDD vgp {vsg}
Vdd VDD 0 1.8
XMplvt 0 vgp VDD VDD sky130_fd_pr__pfet_01v8_lvt L=0.35 W=1000 nf=50 ad=0.29 as=0.29 pd=2.58 ps=2.58 nrd=0.29 nrs=0.29 sa=0 sb=0 sd=0
+ mult=1
XMp 0 vgp VDD VDD sky130_fd_pr__pfet_01v8 L=0.5 W=10 nf=1 ad=0.29 as=0.29 pd=2.58 ps=2.58 nrd=0.29 nrs=0.29 sa=0 sb=0 sd=0 mult=1
XMnlvt VDD vgn 0 0 sky130_fd_pr__nfet_01v8_lvt L=0.35 W=1.0 nf=1 ad=0.29 as=0.29 pd=2.58 ps=2.58 nrd=0.29 nrs=0.29 sa=0 sb=0 sd=0
+ mult=1
XMn VDD vgn 0 0 sky130_fd_pr__nfet_01v8 L=0.5 W=10 nf=1 ad=0.29 as=0.29 pd=2.58 ps=2.58 nrd=0.29 nrs=0.29 sa=0 sb=0 sd=0 mult=1
Vgn vgn 0 {vgs}
**** begin user architecture code

* ==============================================================================
* Encabezado: Caracterizador Completo para PMOS y NMOS Sky130 (Std y LVT)
* Descripcion: Control de simulacion para extraer gm, ro, Id, Vth, Vdsat, Vov,
*              Cgg, ft y gm/Id de los 4 transistores (Mplvt, Mp, Mnlvt, Mn).
* ==============================================================================

* 1. Inclusión de libreria de modelos Sky130 PRIMERO
.lib /foss/pdks/sky130A/libs.tech/ngspice/sky130.lib.spice tt

* Parametros de tension de polarizacion iniciales
.param vsg = 0.6
.param vgs = 0.85

* Parametros de dimensiones geometricas (en micrometros um)
.param wplvt = 1
.param lplvt = 0.35

.param wp = 1
.param lp = 0.15

.param wnlvt = 1
.param lnlvt = 0.35

.param wn = 1
.param ln = 0.15

.control
  * Forzar comportamiento estandar de SPICE para evitar errores numparam en Sky130
  set ngbehavior=ps

  save all

  * --- 1. GUARDAR PARAMETROS PMOS LVT (xMplvt) ---
  save @m.xMplvt.msky130_fd_pr__pfet_01v8_lvt[gm]
  save @m.xMplvt.msky130_fd_pr__pfet_01v8_lvt[gds]
  save @m.xMplvt.msky130_fd_pr__pfet_01v8_lvt[id]
  save @m.xMplvt.msky130_fd_pr__pfet_01v8_lvt[vth]
  save @m.xMplvt.msky130_fd_pr__pfet_01v8_lvt[vdsat]
  save @m.xMplvt.msky130_fd_pr__pfet_01v8_lvt[cgg]
  save @m.xMplvt.msky130_fd_pr__pfet_01v8_lvt[vgs]

  * --- 2. GUARDAR PARAMETROS PMOS ESTANDAR (xMp) ---
  save @m.xMp.msky130_fd_pr__pfet_01v8[gm]
  save @m.xMp.msky130_fd_pr__pfet_01v8[gds]
  save @m.xMp.msky130_fd_pr__pfet_01v8[id]
  save @m.xMp.msky130_fd_pr__pfet_01v8[vth]
  save @m.xMp.msky130_fd_pr__pfet_01v8[vdsat]
  save @m.xMp.msky130_fd_pr__pfet_01v8[cgg]
  save @m.xMp.msky130_fd_pr__pfet_01v8[vgs]

  * --- 3. GUARDAR PARAMETROS NMOS LVT (xMnlvt) ---
  save @m.xMnlvt.msky130_fd_pr__nfet_01v8_lvt[gm]
  save @m.xMnlvt.msky130_fd_pr__nfet_01v8_lvt[gds]
  save @m.xMnlvt.msky130_fd_pr__nfet_01v8_lvt[id]
  save @m.xMnlvt.msky130_fd_pr__nfet_01v8_lvt[vth]
  save @m.xMnlvt.msky130_fd_pr__nfet_01v8_lvt[vdsat]
  save @m.xMnlvt.msky130_fd_pr__nfet_01v8_lvt[cgg]
  save @m.xMnlvt.msky130_fd_pr__nfet_01v8_lvt[vgs]

  * --- 4. GUARDAR PARAMETROS NMOS ESTANDAR (xMn) ---
  save @m.xMn.msky130_fd_pr__nfet_01v8[gm]
  save @m.xMn.msky130_fd_pr__nfet_01v8[gds]
  save @m.xMn.msky130_fd_pr__nfet_01v8[id]
  save @m.xMn.msky130_fd_pr__nfet_01v8[vth]
  save @m.xMn.msky130_fd_pr__nfet_01v8[vdsat]
  save @m.xMn.msky130_fd_pr__nfet_01v8[cgg]
  save @m.xMn.msky130_fd_pr__nfet_01v8[vgs]

  * Barrido DC de fuentes de voltaje Vgp (PMOS) y Vgn (NMOS) de 0V a 1.8V
  dc Vgp 0.0 1.8 0.01 Vgn 0.0 1.8 0.01

  * --- CALCULOS PMOS LVT (Mplvt) ---
  let ro_mplvt = 1 / @m.xMplvt.msky130_fd_pr__pfet_01v8_lvt[gds]
  let gm_id_mplvt = @m.xMplvt.msky130_fd_pr__pfet_01v8_lvt[gm] / @m.xMplvt.msky130_fd_pr__pfet_01v8_lvt[id]
  let ft_mplvt = @m.xMplvt.msky130_fd_pr__pfet_01v8_lvt[gm] / (2 * pi * @m.xMplvt.msky130_fd_pr__pfet_01v8_lvt[cgg])
  let vov_mplvt = abs(@m.xMplvt.msky130_fd_pr__pfet_01v8_lvt[vgs]) - abs(@m.xMplvt.msky130_fd_pr__pfet_01v8_lvt[vth])

  * --- CALCULOS PMOS STD (Mp) ---
  let ro_mp = 1 / @m.xMp.msky130_fd_pr__pfet_01v8[gds]
  let gm_id_mp = @m.xMp.msky130_fd_pr__pfet_01v8[gm] / @m.xMp.msky130_fd_pr__pfet_01v8[id]
  let ft_mp = @m.xMp.msky130_fd_pr__pfet_01v8[gm] / (2 * pi * @m.xMp.msky130_fd_pr__pfet_01v8[cgg])
  let vov_mp = abs(@m.xMp.msky130_fd_pr__pfet_01v8[vgs]) - abs(@m.xMp.msky130_fd_pr__pfet_01v8[vth])

  * --- CALCULOS NMOS LVT (Mnlvt) ---
  let ro_mnlvt = 1 / @m.xMnlvt.msky130_fd_pr__nfet_01v8_lvt[gds]
  let gm_id_mnlvt = @m.xMnlvt.msky130_fd_pr__nfet_01v8_lvt[gm] / @m.xMnlvt.msky130_fd_pr__nfet_01v8_lvt[id]
  let ft_mnlvt = @m.xMnlvt.msky130_fd_pr__nfet_01v8_lvt[gm] / (2 * pi * @m.xMnlvt.msky130_fd_pr__nfet_01v8_lvt[cgg])
  let vov_mnlvt = @m.xMnlvt.msky130_fd_pr__nfet_01v8_lvt[vgs] - @m.xMnlvt.msky130_fd_pr__nfet_01v8_lvt[vth]

  * --- CALCULOS NMOS STD (Mn) ---
  let ro_mn = 1 / @m.xMn.msky130_fd_pr__nfet_01v8[gds]
  let gm_id_mn = @m.xMn.msky130_fd_pr__nfet_01v8[gm] / @m.xMn.msky130_fd_pr__nfet_01v8[id]
  let ft_mn = @m.xMn.msky130_fd_pr__nfet_01v8[gm] / (2 * pi * @m.xMn.msky130_fd_pr__nfet_01v8[cgg])
  let vov_mn = @m.xMn.msky130_fd_pr__nfet_01v8[vgs] - @m.xMn.msky130_fd_pr__nfet_01v8[vth]

  * Guardar los resultados en archivo caracterizador.raw
  set filetype=ascii
  write caracterizador.raw all
.endc

**** end user architecture code
**.ends
.end
