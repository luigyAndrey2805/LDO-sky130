** sch_path: /foss/designs/LDO-sky130/xschem/OTA_tb.sch
**.subckt OTA_tb
x1 net1 vo vin vip net2 0 OTA
V1 net1 0 {VDD}
I0 net1 net2 10u
V2 net3 0 PWL(0 0.0 10m 1.8)
V3 vip net3 ac {VAC}
L4 vo vin 1Meg
C1 vin 0 1
**** begin user architecture code

* 1. Inclusión de libreria de modelos Sky130 PRIMERO
.lib /foss/pdks/sky130A/libs.tech/ngspice/sky130.lib.spice tt

**parametros_ota
.param VDD = 1.8
.param VCM = 1.2
.param VAC = 1

.control

save all
  set filetype=ascii
op

* ==========================================
* TRANSISTORES PMOS (pfet_01v8) dentro de x1
* ==========================================

* Transistor Mnr (Carga de espejo izquierdo)
save @m.x1.xMnr.msky130_fd_pr__pfet_01v8[gm]
save @m.x1.xMnr.msky130_fd_pr__pfet_01v8[gds]
save @m.x1.xMnr.msky130_fd_pr__pfet_01v8[id]
save @m.x1.xMnr.msky130_fd_pr__pfet_01v8[vdsat]

* Transistor Mpr (Carga de espejo derecho)
save @m.x1.xMpr.msky130_fd_pr__pfet_01v8[gm]
save @m.x1.xMpr.msky130_fd_pr__pfet_01v8[gds]
save @m.x1.xMpr.msky130_fd_pr__pfet_01v8[id]
save @m.x1.xMpr.msky130_fd_pr__pfet_01v8[vdsat]

* Transistor Mo (Salida / Segunda etapa superior)
save @m.x1.xMo.msky130_fd_pr__pfet_01v8[gm]
save @m.x1.xMo.msky130_fd_pr__pfet_01v8[gds]
save @m.x1.xMo.msky130_fd_pr__pfet_01v8[id]
save @m.x1.xMo.msky130_fd_pr__pfet_01v8[vdsat]

* ==========================================
* TRANSISTORES NMOS (nfet_01v8) dentro de x1
* ==========================================

* Transistor Mn (Par diferencial izquierdo)
save @m.x1.xMn.msky130_fd_pr__nfet_01v8[gm]
save @m.x1.xMn.msky130_fd_pr__nfet_01v8[gds]
save @m.x1.xMn.msky130_fd_pr__nfet_01v8[id]
save @m.x1.xMn.msky130_fd_pr__nfet_01v8[vdsat]

* Transistor Mp (Par diferencial derecho)
save @m.x1.xMp.msky130_fd_pr__nfet_01v8[gm]
save @m.x1.xMp.msky130_fd_pr__nfet_01v8[gds]
save @m.x1.xMp.msky130_fd_pr__nfet_01v8[id]
save @m.x1.xMp.msky130_fd_pr__nfet_01v8[vdsat]

* Transistor Mr (Referencia de corriente)
save @m.x1.xMr.msky130_fd_pr__nfet_01v8[gm]
save @m.x1.xMr.msky130_fd_pr__nfet_01v8[gds]
save @m.x1.xMr.msky130_fd_pr__nfet_01v8[id]
save @m.x1.xMr.msky130_fd_pr__nfet_01v8[vdsat]

* Transistor Mrc1 (Fuente de corriente de cola / Tail)
save @m.x1.xMrc1.msky130_fd_pr__nfet_01v8[gm]
save @m.x1.xMrc1.msky130_fd_pr__nfet_01v8[gds]
save @m.x1.xMrc1.msky130_fd_pr__nfet_01v8[id]
save @m.x1.xMrc1.msky130_fd_pr__nfet_01v8[vdsat]

* Transistor Mc2 (Salida / Segunda etapa inferior)
save @m.x1.xMc2.msky130_fd_pr__nfet_01v8[gm]
save @m.x1.xMc2.msky130_fd_pr__nfet_01v8[gds]
save @m.x1.xMc2.msky130_fd_pr__nfet_01v8[id]
save @m.x1.xMc2.msky130_fd_pr__nfet_01v8[vdsat]

  * Análisis AC: barrido logarítmico (décadas), 10 puntos por década, de 1 Hz a 1 GHz
tran 10u 10m

* Graficar Magnitud en dB
* plot vdb(vo)

* Graficar Fase en grados (usando cph) o fase directa
* plot cph(v(vo))*180/PI

write OTA_tb_tran.raw all

.endc

**** end user architecture code
**.ends

* expanding   symbol:  OTA.sym # of pins=6
** sym_path: /foss/designs/LDO-sky130/xschem/OTA.sym
** sch_path: /foss/designs/LDO-sky130/xschem/OTA.sch
.subckt OTA VDD VO_ota VIN_ota VIP_ota Iref VSS
*.ipin VIN_ota
*.opin VO_ota
*.iopin Iref
*.iopin VSS
*.iopin VDD
*.ipin VIP_ota
XMr Iref Iref VSS VSS sky130_fd_pr__nfet_01v8 L=0.15 W=1 nf=1 ad=0.29 as=0.29 pd=2.58 ps=2.58 nrd=0.29 nrs=0.29 sa=0 sb=0 sd=0
+ mult=1
XMo VO_ota VO_ota VDD VDD sky130_fd_pr__pfet_01v8 L=0.15 W=1 nf=1 ad=0.29 as=0.29 pd=2.58 ps=2.58 nrd=0.29 nrs=0.29 sa=0 sb=0 sd=0
+ mult=1
XMrc1 Vtail Iref VSS VSS sky130_fd_pr__nfet_01v8 L=0.15 W=1 nf=1 ad=0.29 as=0.29 pd=2.58 ps=2.58 nrd=0.29 nrs=0.29 sa=0 sb=0 sd=0
+ mult=1
XMc2 VO_ota Iref VSS VSS sky130_fd_pr__nfet_01v8 L=0.15 W=1 nf=1 ad=0.29 as=0.29 pd=2.58 ps=2.58 nrd=0.29 nrs=0.29 sa=0 sb=0 sd=0
+ mult=1
XMn VGP VIN_ota Vtail VSS sky130_fd_pr__nfet_01v8 L=0.15 W=1 nf=1 ad=0.29 as=0.29 pd=2.58 ps=2.58 nrd=0.29 nrs=0.29 sa=0 sb=0 sd=0
+ mult=1
XMp VO_ota VIP_ota Vtail VSS sky130_fd_pr__nfet_01v8 L=0.15 W=1 nf=1 ad=0.29 as=0.29 pd=2.58 ps=2.58 nrd=0.29 nrs=0.29 sa=0 sb=0
+ sd=0 mult=1
XMpr VO_ota VGP VDD VDD sky130_fd_pr__pfet_01v8 L=0.15 W=1 nf=1 ad=0.29 as=0.29 pd=2.58 ps=2.58 nrd=0.29 nrs=0.29 sa=0 sb=0 sd=0
+ mult=1
XMnr VGP VGP VDD VDD sky130_fd_pr__pfet_01v8 L=0.15 W=1 nf=1 ad=0.29 as=0.29 pd=2.58 ps=2.58 nrd=0.29 nrs=0.29 sa=0 sb=0 sd=0
+ mult=1
.ends

.end
