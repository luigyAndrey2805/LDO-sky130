* NGSPICE file created from self_bias.ext - technology: sky130A

.subckt self_bias VDD VR VSS
X0 vdi.t0 vgp_self.t23 VDD.t1 VDD.t0 sky130_fd_pr__pfet_01v8_lvt ad=1.25 pd=5.5 as=1.25 ps=5.5 w=5 l=1
X1 vgp_self.t0 vdi.t16 VR.t4 VSS.t0 sky130_fd_pr__nfet_01v8 ad=1 pd=4.5 as=1.2 ps=8.6 w=4 l=1
X2 VDD.t19 vgp_self.t9 vgp_self.t10 VDD.t18 sky130_fd_pr__pfet_01v8_lvt ad=1.25 pd=5.5 as=1.25 ps=5.5 w=5 l=1
X3 VR.t0 vdi.t11 vgp_self.t5 VSS.t0 sky130_fd_pr__nfet_01v8 ad=1.2 pd=8.6 as=1 ps=4.5 w=4 l=1
X4 VR.t2 vdi.t13 vgp_self.t3 VSS.t0 sky130_fd_pr__nfet_01v8 ad=1 pd=4.5 as=1 ps=4.5 w=4 l=1
X5 VDD.t7 vgp_self.t20 vdi.t2 VDD.t6 sky130_fd_pr__pfet_01v8_lvt ad=1.25 pd=5.5 as=1.25 ps=5.5 w=5 l=1
X6 vdinv.t1 VR.t16 VSS.t14 VSS.t8 sky130_fd_pr__nfet_01v8 ad=1 pd=4.5 as=1.2 ps=8.6 w=4 l=1
X7 vgp_self.t16 vgp_self.t15 VDD.t9 VDD.t8 sky130_fd_pr__pfet_01v8_lvt ad=1.25 pd=5.5 as=1.25 ps=5.5 w=5 l=1
X8 VSS.t5 VR.t6 VSS.t4 sky130_fd_pr__res_xhigh_po_0p69 l=20.7
X9 VDD.t3 vgp_self.t22 vdi.t1 VDD.t2 sky130_fd_pr__pfet_01v8_lvt ad=1.25 pd=5.5 as=1.25 ps=5.5 w=5 l=1
X10 VSS.t11 VR.t15 vdinv.t2 VSS.t8 sky130_fd_pr__nfet_01v8 ad=1 pd=4.5 as=1 ps=4.5 w=4 l=1
X11 vgp_self.t12 vgp_self.t11 VDD.t17 VDD.t16 sky130_fd_pr__pfet_01v8_lvt ad=1.25 pd=5.5 as=1.25 ps=5.5 w=5 l=1
X12 vdinv.t3 VR.t14 VSS.t12 VSS.t8 sky130_fd_pr__nfet_01v8 ad=1 pd=4.5 as=1 ps=4.5 w=4 l=1
X13 vgp_self.t19 vdinv.t7 VSS.t3 VSS.t1 sky130_fd_pr__nfet_01v8 ad=0.25 pd=1.5 as=0.3 ps=2.6 w=1 l=1
X14 vgp_self.t8 vgp_self.t7 VDD.t15 VDD.t14 sky130_fd_pr__pfet_01v8_lvt ad=1.25 pd=5.5 as=1.25 ps=5.5 w=5 l=1
X15 vdi.t4 vgp_self.t25 VDD.t21 VDD.t20 sky130_fd_pr__pfet_01v8_lvt ad=1.25 pd=5.5 as=1.5 ps=10.6 w=5 l=1
X16 VDD.t5 vgp_self.t17 vgp_self.t18 VDD.t4 sky130_fd_pr__pfet_01v8_lvt ad=1.5 pd=10.6 as=1.25 ps=5.5 w=5 l=1
X17 VSS.t2 vdinv.t6 vgp_self.t6 VSS.t1 sky130_fd_pr__nfet_01v8 ad=0.3 pd=2.6 as=0.25 ps=1.5 w=1 l=1
X18 vp2.t1 VR.t18 vp1.t0 VDD.t24 sky130_fd_pr__pfet_01v8_lvt ad=0.15 pd=1.6 as=0.15 ps=1.6 w=0.5 l=5
X19 VDD.t13 vgp_self.t13 vgp_self.t14 VDD.t12 sky130_fd_pr__pfet_01v8_lvt ad=1.25 pd=5.5 as=1.25 ps=5.5 w=5 l=1
X20 VSS.t10 VR.t13 vdinv.t4 VSS.t8 sky130_fd_pr__nfet_01v8 ad=1 pd=4.5 as=1 ps=4.5 w=4 l=1
X21 vp4.t0 VR.t20 vp3.t1 VDD.t24 sky130_fd_pr__pfet_01v8_lvt ad=0.15 pd=1.6 as=0.15 ps=1.6 w=0.5 l=5
X22 vp2.t0 VR.t19 vp3.t0 VDD.t24 sky130_fd_pr__pfet_01v8_lvt ad=0.15 pd=1.6 as=0.15 ps=1.6 w=0.5 l=5
X23 vdi.t6 VR.t11 VSS.t16 VSS.t6 sky130_fd_pr__nfet_01v8 ad=0.25 pd=1.5 as=0.3 ps=2.6 w=1 l=1
X24 vdinv.t5 VR.t12 VSS.t9 VSS.t8 sky130_fd_pr__nfet_01v8 ad=1.2 pd=8.6 as=1 ps=4.5 w=4 l=1
X25 VDD.t23 vgp_self.t24 vdi.t5 VDD.t22 sky130_fd_pr__pfet_01v8_lvt ad=1.25 pd=5.5 as=1.25 ps=5.5 w=5 l=1
X26 VSS.t15 VR.t10 vdi.t7 VSS.t6 sky130_fd_pr__nfet_01v8 ad=0.25 pd=1.5 as=0.25 ps=1.5 w=1 l=1
X27 vdi.t10 VR.t7 VSS.t17 VSS.t6 sky130_fd_pr__nfet_01v8 ad=0.3 pd=2.6 as=0.25 ps=1.5 w=1 l=1
X28 vdi.t8 VR.t9 VSS.t7 VSS.t6 sky130_fd_pr__nfet_01v8 ad=0.25 pd=1.5 as=0.25 ps=1.5 w=1 l=1
X29 vp4.t1 VR.t21 VDD.t25 VDD.t24 sky130_fd_pr__pfet_01v8_lvt ad=0.15 pd=1.6 as=0.15 ps=1.6 w=0.5 l=5
X30 VR.t3 vdi.t15 vgp_self.t1 VSS.t0 sky130_fd_pr__nfet_01v8 ad=1 pd=4.5 as=1 ps=4.5 w=4 l=1
X31 vdi.t3 vgp_self.t21 VDD.t11 VDD.t10 sky130_fd_pr__pfet_01v8_lvt ad=1.25 pd=5.5 as=1.25 ps=5.5 w=5 l=1
X32 vdinv.t0 VR.t17 vp1.t1 VDD.t24 sky130_fd_pr__pfet_01v8_lvt ad=0.15 pd=1.6 as=0.15 ps=1.6 w=0.5 l=5
X33 vgp_self.t4 vdi.t12 VR.t5 VSS.t0 sky130_fd_pr__nfet_01v8 ad=1 pd=4.5 as=1 ps=4.5 w=4 l=1
X34 VSS.t13 VR.t8 vdi.t9 VSS.t6 sky130_fd_pr__nfet_01v8 ad=0.25 pd=1.5 as=0.25 ps=1.5 w=1 l=1
X35 vgp_self.t2 vdi.t14 VR.t1 VSS.t0 sky130_fd_pr__nfet_01v8 ad=1 pd=4.5 as=1 ps=4.5 w=4 l=1
R0 VR.n99 VR.n19 184.74
R1 VR.n104 VR.n17 184.74
R2 VR.n109 VR.n15 184.74
R3 VR.n94 VR.n22 184.74
R4 VR.n74 VR.n29 184.74
R5 VR.n79 VR.n28 184.74
R6 VR.n84 VR.n26 184.74
R7 VR.n89 VR.n24 184.74
R8 VR.n46 VR.n45 152
R9 VR.n40 VR.n39 152
R10 VR.n52 VR.n51 152
R11 VR.n53 VR.n38 152
R12 VR.n57 VR.n56 152
R13 VR.n55 VR.n35 152
R14 VR.n61 VR.n36 152
R15 VR.n62 VR.n34 152
R16 VR.n65 VR.n64 152
R17 VR.n69 VR.t16 148.065
R18 VR.n66 VR.n65 110.293
R19 VR.n29 VR.t15 96.4005
R20 VR.n28 VR.t14 96.4005
R21 VR.n26 VR.t13 96.4005
R22 VR.n24 VR.t12 96.4005
R23 VR.n45 VR.n44 92.41
R24 VR.n118 VR.n117 86.1871
R25 VR.n127 VR.n126 86.1871
R26 VR.n11 VR.n10 86.1871
R27 VR.n3 VR.n1 86.1871
R28 VR.n20 VR.n19 77.1778
R29 VR.n18 VR.n17 77.1778
R30 VR.n16 VR.n15 77.1778
R31 VR.n92 VR.n22 77.1778
R32 VR.n30 VR.n29 77.1778
R33 VR.n77 VR.n28 77.1778
R34 VR.n82 VR.n26 77.1778
R35 VR.n87 VR.n24 77.1778
R36 VR.n14 VR.t7 75.7623
R37 VR.n116 VR.n115 33.1022
R38 VR.n125 VR.n124 33.1022
R39 VR.n9 VR.n8 33.1022
R40 VR.n4 VR.n2 33.1022
R41 VR.n45 VR.n39 33.0519
R42 VR.n52 VR.n39 33.0519
R43 VR.n53 VR.n52 33.0519
R44 VR.n56 VR.n55 33.0519
R45 VR.n55 VR.n36 33.0519
R46 VR.n36 VR.n34 33.0519
R47 VR.n65 VR.n34 33.0519
R48 VR.n111 VR.n14 27.631
R49 VR.n70 VR.n69 27.6288
R50 VR.n99 VR.n98 27.1064
R51 VR.n104 VR.n103 27.1064
R52 VR.n109 VR.n108 27.1064
R53 VR.n94 VR.n93 27.1064
R54 VR.n74 VR.n73 27.1064
R55 VR.n79 VR.n78 27.1064
R56 VR.n46 VR.n42 27.1064
R57 VR.n46 VR.n40 27.1064
R58 VR.n51 VR.n40 27.1064
R59 VR.n51 VR.n38 27.1064
R60 VR.n57 VR.n38 27.1064
R61 VR.n57 VR.n35 27.1064
R62 VR.n61 VR.n35 27.1064
R63 VR.n62 VR.n61 27.1064
R64 VR.n64 VR.n62 27.1064
R65 VR.n64 VR.n33 27.1064
R66 VR.n84 VR.n83 27.1064
R67 VR.n89 VR.n88 27.1064
R68 VR.n19 VR.t10 24.1005
R69 VR.n17 VR.t9 24.1005
R70 VR.n15 VR.t8 24.1005
R71 VR.n22 VR.t11 24.1005
R72 VR.n67 VR.n66 23.0752
R73 VR.n96 VR.n20 23.0638
R74 VR.n101 VR.n18 23.0638
R75 VR.n106 VR.n16 23.0638
R76 VR.n92 VR.n91 23.0638
R77 VR.n71 VR.n30 23.0638
R78 VR.n77 VR.n76 23.0638
R79 VR.n82 VR.n81 23.0638
R80 VR.n87 VR.n86 23.0638
R81 VR VR.t6 22.02
R82 VR.n12 VR.n11 21.9626
R83 VR.n134 VR.n1 21.9626
R84 VR VR.n118 21.9322
R85 VR VR.n127 21.9322
R86 VR.n117 VR.n116 20.9826
R87 VR.n126 VR.n125 20.9826
R88 VR.n10 VR.n9 20.9826
R89 VR.n4 VR.n3 20.9826
R90 VR.n54 VR.n53 16.5262
R91 VR.n56 VR.n54 16.5262
R92 VR.n44 VR.n43 16.479
R93 VR.n44 VR.n42 15.0603
R94 VR.n112 VR.n14 13.1975
R95 VR.n69 VR.n68 13.1811
R96 VR.n118 VR.n115 12.6288
R97 VR.n127 VR.n124 12.6288
R98 VR.n11 VR.n8 12.6288
R99 VR.n2 VR.n1 12.6288
R100 VR.n98 VR.n20 11.3247
R101 VR.n103 VR.n18 11.3247
R102 VR.n108 VR.n16 11.3247
R103 VR.n93 VR.n92 11.3247
R104 VR.n73 VR.n30 11.3247
R105 VR.n78 VR.n77 11.3247
R106 VR.n83 VR.n82 11.3247
R107 VR.n88 VR.n87 11.3247
R108 VR.n66 VR.n33 11.3151
R109 VR.n121 VR.n112 9.66661
R110 VR.n64 VR.n63 9.3005
R111 VR.n33 VR.n32 9.3005
R112 VR.n62 VR.n31 9.3005
R113 VR.n38 VR.n37 9.3005
R114 VR.n58 VR.n57 9.3005
R115 VR.n59 VR.n35 9.3005
R116 VR.n61 VR.n60 9.3005
R117 VR.n42 VR.n41 9.3005
R118 VR.n47 VR.n46 9.3005
R119 VR.n48 VR.n40 9.3005
R120 VR.n51 VR.n50 9.3005
R121 VR.n88 VR.n23 9.3005
R122 VR.n90 VR.n89 9.3005
R123 VR.n83 VR.n25 9.3005
R124 VR.n85 VR.n84 9.3005
R125 VR.n78 VR.n27 9.3005
R126 VR.n80 VR.n79 9.3005
R127 VR.n73 VR.n72 9.3005
R128 VR.n75 VR.n74 9.3005
R129 VR.n93 VR.n21 9.3005
R130 VR.n108 VR.n107 9.3005
R131 VR.n110 VR.n109 9.3005
R132 VR.n103 VR.n102 9.3005
R133 VR.n105 VR.n104 9.3005
R134 VR.n98 VR.n97 9.3005
R135 VR.n100 VR.n99 9.3005
R136 VR.n95 VR.n94 9.3005
R137 VR.n115 VR.n114 9.3005
R138 VR.n124 VR.n123 9.3005
R139 VR.n8 VR.n7 9.3005
R140 VR.n2 VR.n0 9.3005
R141 VR.t20 VR.t21 8.6765
R142 VR.t19 VR.t20 8.6765
R143 VR.t18 VR.t19 8.6765
R144 VR.t17 VR.t18 8.4837
R145 VR.n126 VR.t1 7.5005
R146 VR.n126 VR.t3 7.5005
R147 VR.n3 VR.t5 7.5005
R148 VR.n3 VR.t2 7.5005
R149 VR.n131 VR 5.59905
R150 VR.n120 VR.n113 4.55422
R151 VR.n120 VR.n119 4.55422
R152 VR.n129 VR.n122 4.55422
R153 VR.n129 VR.n128 4.55422
R154 VR.n13 VR.n6 4.55422
R155 VR.n13 VR.n12 4.55422
R156 VR.n133 VR.n5 4.55422
R157 VR.n134 VR.n133 4.55422
R158 VR.n117 VR.t4 4.5005
R159 VR.n10 VR.t0 4.5005
R160 VR.n54 VR.t17 2.4105
R161 VR.n132 VR.n13 2.09678
R162 VR.n121 VR.n120 1.69885
R163 VR.n130 VR.n129 1.69885
R164 VR.n133 VR.n132 1.69885
R165 VR.n68 VR.n67 1.29843
R166 VR.n116 VR.n113 1.21288
R167 VR.n125 VR.n122 1.21288
R168 VR.n9 VR.n6 1.21288
R169 VR.n5 VR.n4 1.21288
R170 VR.n72 VR.n31 1.183
R171 VR.n49 VR.n27 1.183
R172 VR.n43 VR.n25 1.183
R173 VR.n91 VR.n90 0.987327
R174 VR.n130 VR.n121 0.3953
R175 VR.n86 VR.n85 0.3905
R176 VR.n81 VR.n80 0.3905
R177 VR.n76 VR.n75 0.3905
R178 VR.n71 VR.n70 0.3905
R179 VR.n111 VR.n110 0.3905
R180 VR.n106 VR.n105 0.3905
R181 VR.n101 VR.n100 0.3905
R182 VR.n96 VR.n95 0.3905
R183 VR.n131 VR.n130 0.203439
R184 VR.n132 VR.n131 0.200305
R185 VR.n63 VR.n32 0.196152
R186 VR.n67 VR.n32 0.196152
R187 VR.n58 VR.n37 0.196152
R188 VR.n60 VR.n59 0.196152
R189 VR.n47 VR.n41 0.196152
R190 VR.n48 VR.n47 0.196152
R191 VR.n50 VR.n48 0.196152
R192 VR.n90 VR.n23 0.1805
R193 VR.n85 VR.n25 0.1805
R194 VR.n80 VR.n27 0.1805
R195 VR.n72 VR.n71 0.1805
R196 VR.n107 VR.n106 0.1805
R197 VR.n102 VR.n101 0.1805
R198 VR.n97 VR.n96 0.1805
R199 VR.n95 VR.n21 0.175212
R200 VR.n63 VR.n31 0.166261
R201 VR VR.n58 0.149957
R202 VR.n86 VR 0.138
R203 VR.n81 VR 0.138
R204 VR.n76 VR 0.138
R205 VR.n75 VR 0.138
R206 VR.n70 VR 0.138
R207 VR.n110 VR 0.138
R208 VR.n105 VR 0.138
R209 VR.n100 VR 0.138
R210 VR.n91 VR 0.132712
R211 VR.n60 VR.n31 0.0901739
R212 VR.n119 VR.n114 0.0883378
R213 VR.n128 VR.n123 0.0883378
R214 VR VR.n111 0.07675
R215 VR.n50 VR.n49 0.0575652
R216 VR.n7 VR 0.0545541
R217 VR VR.n0 0.0545541
R218 VR.n59 VR 0.0466957
R219 VR VR.n23 0.043
R220 VR VR.n25 0.043
R221 VR VR.n27 0.043
R222 VR.n72 VR 0.043
R223 VR.n68 VR 0.043
R224 VR.n107 VR 0.043
R225 VR.n102 VR 0.043
R226 VR.n97 VR 0.043
R227 VR VR.n21 0.0413654
R228 VR.n43 VR.n41 0.0358261
R229 VR.n12 VR 0.0342838
R230 VR VR.n134 0.0342838
R231 VR.n119 VR 0.0309054
R232 VR.n128 VR 0.0309054
R233 VR.n114 VR.n113 0.0207703
R234 VR.n123 VR.n122 0.0207703
R235 VR.n7 VR.n6 0.0207703
R236 VR.n5 VR.n0 0.0207703
R237 VR.n49 VR.n37 0.00321739
R238 VR.n112 VR 0.00175
R239 VDD.n727 VDD.t25 644.101
R240 VDD.n406 VDD.n183 592.942
R241 VDD.n615 VDD.n62 592.942
R242 VDD.n404 VDD.n185 592.942
R243 VDD.n541 VDD.n59 592.942
R244 VDD.n585 VDD.n584 585
R245 VDD.n345 VDD.n113 585
R246 VDD.n313 VDD.n130 585
R247 VDD.n280 VDD.n279 585
R248 VDD.n388 VDD.n387 585
R249 VDD.n83 VDD.n66 289.519
R250 VDD.n585 VDD.n92 285.877
R251 VDD.n585 VDD.n91 285.877
R252 VDD.n585 VDD.n90 285.877
R253 VDD.n585 VDD.n89 285.877
R254 VDD.n585 VDD.n87 285.877
R255 VDD.n586 VDD.n585 285.877
R256 VDD.n345 VDD.n344 285.877
R257 VDD.n346 VDD.n345 285.877
R258 VDD.n345 VDD.n343 285.877
R259 VDD.n345 VDD.n326 285.877
R260 VDD.n345 VDD.n325 285.877
R261 VDD.n345 VDD.n324 285.877
R262 VDD.n313 VDD.n312 285.877
R263 VDD.n314 VDD.n313 285.877
R264 VDD.n313 VDD.n311 285.877
R265 VDD.n313 VDD.n293 285.877
R266 VDD.n313 VDD.n292 285.877
R267 VDD.n313 VDD.n291 285.877
R268 VDD.n280 VDD.n262 285.877
R269 VDD.n281 VDD.n280 285.877
R270 VDD.n280 VDD.n261 285.877
R271 VDD.n280 VDD.n260 285.877
R272 VDD.n280 VDD.n259 285.877
R273 VDD.n280 VDD.n258 285.877
R274 VDD.n398 VDD.n221 285.877
R275 VDD.n398 VDD.n222 285.877
R276 VDD.n398 VDD.n223 285.877
R277 VDD.n398 VDD.n224 285.877
R278 VDD.n398 VDD.n397 285.877
R279 VDD.n83 VDD.n69 285.877
R280 VDD.n83 VDD.n70 285.877
R281 VDD.n83 VDD.n82 285.877
R282 VDD.n388 VDD.n233 285.877
R283 VDD.n388 VDD.n232 285.877
R284 VDD.n388 VDD.n231 285.877
R285 VDD.n389 VDD.n388 285.877
R286 VDD.n406 VDD.n181 254.119
R287 VDD.n410 VDD.n181 254.119
R288 VDD.n410 VDD.n175 254.119
R289 VDD.n418 VDD.n175 254.119
R290 VDD.n418 VDD.n173 254.119
R291 VDD.n422 VDD.n173 254.119
R292 VDD.n422 VDD.n167 254.119
R293 VDD.n430 VDD.n167 254.119
R294 VDD.n430 VDD.n165 254.119
R295 VDD.n434 VDD.n165 254.119
R296 VDD.n434 VDD.n159 254.119
R297 VDD.n442 VDD.n159 254.119
R298 VDD.n442 VDD.n157 254.119
R299 VDD.n446 VDD.n157 254.119
R300 VDD.n446 VDD.n151 254.119
R301 VDD.n454 VDD.n151 254.119
R302 VDD.n454 VDD.n149 254.119
R303 VDD.n458 VDD.n149 254.119
R304 VDD.n458 VDD.n142 254.119
R305 VDD.n468 VDD.n142 254.119
R306 VDD.n468 VDD.n140 254.119
R307 VDD.n472 VDD.n140 254.119
R308 VDD.n472 VDD.n136 254.119
R309 VDD.n478 VDD.n136 254.119
R310 VDD.n478 VDD.n134 254.119
R311 VDD.n482 VDD.n134 254.119
R312 VDD.n482 VDD.n127 254.119
R313 VDD.n491 VDD.n127 254.119
R314 VDD.n491 VDD.n125 254.119
R315 VDD.n495 VDD.n125 254.119
R316 VDD.n495 VDD.n119 254.119
R317 VDD.n503 VDD.n119 254.119
R318 VDD.n503 VDD.n117 254.119
R319 VDD.n507 VDD.n117 254.119
R320 VDD.n507 VDD.n110 254.119
R321 VDD.n515 VDD.n110 254.119
R322 VDD.n515 VDD.n108 254.119
R323 VDD.n519 VDD.n108 254.119
R324 VDD.n519 VDD.n102 254.119
R325 VDD.n527 VDD.n102 254.119
R326 VDD.n527 VDD.n99 254.119
R327 VDD.n580 VDD.n99 254.119
R328 VDD.n580 VDD.n100 254.119
R329 VDD.n576 VDD.n100 254.119
R330 VDD.n576 VDD.n531 254.119
R331 VDD.n572 VDD.n531 254.119
R332 VDD.n572 VDD.n536 254.119
R333 VDD.n568 VDD.n536 254.119
R334 VDD.n568 VDD.n538 254.119
R335 VDD.n564 VDD.n538 254.119
R336 VDD.n564 VDD.n62 254.119
R337 VDD.n196 VDD.n194 254.119
R338 VDD.n200 VDD.n191 254.119
R339 VDD.n204 VDD.n202 254.119
R340 VDD.n208 VDD.n189 254.119
R341 VDD.n211 VDD.n210 254.119
R342 VDD.n215 VDD.n214 254.119
R343 VDD.n404 VDD.n179 254.119
R344 VDD.n412 VDD.n179 254.119
R345 VDD.n412 VDD.n177 254.119
R346 VDD.n416 VDD.n177 254.119
R347 VDD.n416 VDD.n171 254.119
R348 VDD.n424 VDD.n171 254.119
R349 VDD.n424 VDD.n169 254.119
R350 VDD.n428 VDD.n169 254.119
R351 VDD.n428 VDD.n163 254.119
R352 VDD.n436 VDD.n163 254.119
R353 VDD.n436 VDD.n161 254.119
R354 VDD.n440 VDD.n161 254.119
R355 VDD.n440 VDD.n154 254.119
R356 VDD.n448 VDD.n154 254.119
R357 VDD.n448 VDD.n152 254.119
R358 VDD.n452 VDD.n152 254.119
R359 VDD.n452 VDD.n146 254.119
R360 VDD.n460 VDD.n146 254.119
R361 VDD.n460 VDD.n143 254.119
R362 VDD.n466 VDD.n143 254.119
R363 VDD.n466 VDD.n144 254.119
R364 VDD.n144 VDD.n137 254.119
R365 VDD.n475 VDD.n137 254.119
R366 VDD.n476 VDD.n475 254.119
R367 VDD.n476 VDD.n131 254.119
R368 VDD.n484 VDD.n128 254.119
R369 VDD.n489 VDD.n128 254.119
R370 VDD.n489 VDD.n122 254.119
R371 VDD.n497 VDD.n122 254.119
R372 VDD.n497 VDD.n120 254.119
R373 VDD.n501 VDD.n120 254.119
R374 VDD.n501 VDD.n114 254.119
R375 VDD.n509 VDD.n114 254.119
R376 VDD.n509 VDD.n111 254.119
R377 VDD.n513 VDD.n111 254.119
R378 VDD.n513 VDD.n106 254.119
R379 VDD.n521 VDD.n106 254.119
R380 VDD.n521 VDD.n104 254.119
R381 VDD.n525 VDD.n104 254.119
R382 VDD.n525 VDD.n95 254.119
R383 VDD.n582 VDD.n95 254.119
R384 VDD.n582 VDD.n96 254.119
R385 VDD.n532 VDD.n96 254.119
R386 VDD.n533 VDD.n532 254.119
R387 VDD.n534 VDD.n533 254.119
R388 VDD.n545 VDD.n534 254.119
R389 VDD.n545 VDD.n539 254.119
R390 VDD.n540 VDD.n539 254.119
R391 VDD.n562 VDD.n540 254.119
R392 VDD.n562 VDD.n541 254.119
R393 VDD.n61 VDD.n60 254.119
R394 VDD.n610 VDD.n60 254.119
R395 VDD.n608 VDD.n607 254.119
R396 VDD.n604 VDD.n603 254.119
R397 VDD.n600 VDD.n599 254.119
R398 VDD.n551 VDD.n550 254.119
R399 VDD.n555 VDD.n554 254.119
R400 VDD.n557 VDD.n59 254.119
R401 VDD.n399 VDD.n398 189.631
R402 VDD.n615 VDD.n614 185
R403 VDD.n613 VDD.n61 185
R404 VDD.n612 VDD.n60 185
R405 VDD.n617 VDD.n60 185
R406 VDD.n611 VDD.n610 185
R407 VDD.n609 VDD.n608 185
R408 VDD.n607 VDD.n606 185
R409 VDD.n605 VDD.n604 185
R410 VDD.n603 VDD.n602 185
R411 VDD.n601 VDD.n600 185
R412 VDD.n599 VDD.n64 185
R413 VDD.n550 VDD.n549 185
R414 VDD.n552 VDD.n551 185
R415 VDD.n554 VDD.n553 185
R416 VDD.n556 VDD.n555 185
R417 VDD.n558 VDD.n557 185
R418 VDD.n559 VDD.n59 185
R419 VDD.n617 VDD.n59 185
R420 VDD.n560 VDD.n541 185
R421 VDD.n541 VDD.n52 185
R422 VDD.n562 VDD.n561 185
R423 VDD.n565 VDD.n562 185
R424 VDD.n548 VDD.n540 185
R425 VDD.n566 VDD.n540 185
R426 VDD.n547 VDD.n539 185
R427 VDD.n567 VDD.n539 185
R428 VDD.n546 VDD.n545 185
R429 VDD.n545 VDD.n535 185
R430 VDD.n544 VDD.n534 185
R431 VDD.n573 VDD.n534 185
R432 VDD.n543 VDD.n533 185
R433 VDD.n574 VDD.n533 185
R434 VDD.n542 VDD.n532 185
R435 VDD.n575 VDD.n532 185
R436 VDD.n96 VDD.n94 185
R437 VDD.n98 VDD.n96 185
R438 VDD.n583 VDD.n582 185
R439 VDD.n582 VDD.n581 185
R440 VDD.n95 VDD.n93 185
R441 VDD.n97 VDD.n95 185
R442 VDD.n525 VDD.n524 185
R443 VDD.n526 VDD.n525 185
R444 VDD.n523 VDD.n104 185
R445 VDD.n104 VDD.n103 185
R446 VDD.n522 VDD.n521 185
R447 VDD.n521 VDD.n520 185
R448 VDD.n106 VDD.n105 185
R449 VDD.n107 VDD.n106 185
R450 VDD.n513 VDD.n512 185
R451 VDD.n514 VDD.n513 185
R452 VDD.n511 VDD.n111 185
R453 VDD.n116 VDD.n111 185
R454 VDD.n510 VDD.n509 185
R455 VDD.n509 VDD.n508 185
R456 VDD.n114 VDD.n112 185
R457 VDD.n115 VDD.n114 185
R458 VDD.n501 VDD.n500 185
R459 VDD.n502 VDD.n501 185
R460 VDD.n499 VDD.n120 185
R461 VDD.n124 VDD.n120 185
R462 VDD.n498 VDD.n497 185
R463 VDD.n497 VDD.n496 185
R464 VDD.n122 VDD.n121 185
R465 VDD.n123 VDD.n122 185
R466 VDD.n489 VDD.n488 185
R467 VDD.n490 VDD.n489 185
R468 VDD.n487 VDD.n128 185
R469 VDD.n133 VDD.n128 185
R470 VDD.n484 VDD.n483 185
R471 VDD.n132 VDD.n131 185
R472 VDD.n476 VDD.n129 185
R473 VDD.n477 VDD.n476 185
R474 VDD.n475 VDD.n138 185
R475 VDD.n475 VDD.n474 185
R476 VDD.n463 VDD.n137 185
R477 VDD.n473 VDD.n137 185
R478 VDD.n464 VDD.n144 185
R479 VDD.n144 VDD.n139 185
R480 VDD.n466 VDD.n465 185
R481 VDD.n467 VDD.n466 185
R482 VDD.n462 VDD.n143 185
R483 VDD.n148 VDD.n143 185
R484 VDD.n461 VDD.n460 185
R485 VDD.n460 VDD.n459 185
R486 VDD.n146 VDD.n145 185
R487 VDD.n147 VDD.n146 185
R488 VDD.n452 VDD.n451 185
R489 VDD.n453 VDD.n452 185
R490 VDD.n450 VDD.n152 185
R491 VDD.n156 VDD.n152 185
R492 VDD.n449 VDD.n448 185
R493 VDD.n448 VDD.n447 185
R494 VDD.n154 VDD.n153 185
R495 VDD.n155 VDD.n154 185
R496 VDD.n440 VDD.n439 185
R497 VDD.n441 VDD.n440 185
R498 VDD.n438 VDD.n161 185
R499 VDD.n161 VDD.n160 185
R500 VDD.n437 VDD.n436 185
R501 VDD.n436 VDD.n435 185
R502 VDD.n163 VDD.n162 185
R503 VDD.n164 VDD.n163 185
R504 VDD.n428 VDD.n427 185
R505 VDD.n429 VDD.n428 185
R506 VDD.n426 VDD.n169 185
R507 VDD.n169 VDD.n168 185
R508 VDD.n425 VDD.n424 185
R509 VDD.n424 VDD.n423 185
R510 VDD.n171 VDD.n170 185
R511 VDD.n172 VDD.n171 185
R512 VDD.n416 VDD.n415 185
R513 VDD.n417 VDD.n416 185
R514 VDD.n414 VDD.n177 185
R515 VDD.n177 VDD.n176 185
R516 VDD.n413 VDD.n412 185
R517 VDD.n412 VDD.n411 185
R518 VDD.n179 VDD.n178 185
R519 VDD.n180 VDD.n179 185
R520 VDD.n404 VDD.n403 185
R521 VDD.n405 VDD.n404 185
R522 VDD.n402 VDD.n185 185
R523 VDD.n215 VDD.n186 185
R524 VDD.n214 VDD.n213 185
R525 VDD.n212 VDD.n211 185
R526 VDD.n210 VDD.n188 185
R527 VDD.n208 VDD.n207 185
R528 VDD.n206 VDD.n189 185
R529 VDD.n205 VDD.n204 185
R530 VDD.n202 VDD.n190 185
R531 VDD.n200 VDD.n199 185
R532 VDD.n198 VDD.n191 185
R533 VDD.n197 VDD.n196 185
R534 VDD.n194 VDD.n192 185
R535 VDD.n183 VDD.n182 185
R536 VDD.n407 VDD.n406 185
R537 VDD.n406 VDD.n405 185
R538 VDD.n408 VDD.n181 185
R539 VDD.n181 VDD.n180 185
R540 VDD.n410 VDD.n409 185
R541 VDD.n411 VDD.n410 185
R542 VDD.n175 VDD.n174 185
R543 VDD.n176 VDD.n175 185
R544 VDD.n419 VDD.n418 185
R545 VDD.n418 VDD.n417 185
R546 VDD.n420 VDD.n173 185
R547 VDD.n173 VDD.n172 185
R548 VDD.n422 VDD.n421 185
R549 VDD.n423 VDD.n422 185
R550 VDD.n167 VDD.n166 185
R551 VDD.n168 VDD.n167 185
R552 VDD.n431 VDD.n430 185
R553 VDD.n430 VDD.n429 185
R554 VDD.n432 VDD.n165 185
R555 VDD.n165 VDD.n164 185
R556 VDD.n434 VDD.n433 185
R557 VDD.n435 VDD.n434 185
R558 VDD.n159 VDD.n158 185
R559 VDD.n160 VDD.n159 185
R560 VDD.n443 VDD.n442 185
R561 VDD.n442 VDD.n441 185
R562 VDD.n444 VDD.n157 185
R563 VDD.n157 VDD.n155 185
R564 VDD.n446 VDD.n445 185
R565 VDD.n447 VDD.n446 185
R566 VDD.n151 VDD.n150 185
R567 VDD.n156 VDD.n151 185
R568 VDD.n455 VDD.n454 185
R569 VDD.n454 VDD.n453 185
R570 VDD.n456 VDD.n149 185
R571 VDD.n149 VDD.n147 185
R572 VDD.n458 VDD.n457 185
R573 VDD.n459 VDD.n458 185
R574 VDD.n142 VDD.n141 185
R575 VDD.n148 VDD.n142 185
R576 VDD.n469 VDD.n468 185
R577 VDD.n468 VDD.n467 185
R578 VDD.n470 VDD.n140 185
R579 VDD.n140 VDD.n139 185
R580 VDD.n472 VDD.n471 185
R581 VDD.n473 VDD.n472 185
R582 VDD.n136 VDD.n135 185
R583 VDD.n474 VDD.n136 185
R584 VDD.n479 VDD.n478 185
R585 VDD.n478 VDD.n477 185
R586 VDD.n480 VDD.n134 185
R587 VDD.n134 VDD.n132 185
R588 VDD.n482 VDD.n481 185
R589 VDD.n483 VDD.n482 185
R590 VDD.n127 VDD.n126 185
R591 VDD.n133 VDD.n127 185
R592 VDD.n492 VDD.n491 185
R593 VDD.n491 VDD.n490 185
R594 VDD.n493 VDD.n125 185
R595 VDD.n125 VDD.n123 185
R596 VDD.n495 VDD.n494 185
R597 VDD.n496 VDD.n495 185
R598 VDD.n119 VDD.n118 185
R599 VDD.n124 VDD.n119 185
R600 VDD.n504 VDD.n503 185
R601 VDD.n503 VDD.n502 185
R602 VDD.n505 VDD.n117 185
R603 VDD.n117 VDD.n115 185
R604 VDD.n507 VDD.n506 185
R605 VDD.n508 VDD.n507 185
R606 VDD.n110 VDD.n109 185
R607 VDD.n116 VDD.n110 185
R608 VDD.n516 VDD.n515 185
R609 VDD.n515 VDD.n514 185
R610 VDD.n517 VDD.n108 185
R611 VDD.n108 VDD.n107 185
R612 VDD.n519 VDD.n518 185
R613 VDD.n520 VDD.n519 185
R614 VDD.n102 VDD.n101 185
R615 VDD.n103 VDD.n102 185
R616 VDD.n528 VDD.n527 185
R617 VDD.n527 VDD.n526 185
R618 VDD.n529 VDD.n99 185
R619 VDD.n99 VDD.n97 185
R620 VDD.n580 VDD.n579 185
R621 VDD.n581 VDD.n580 185
R622 VDD.n578 VDD.n100 185
R623 VDD.n100 VDD.n98 185
R624 VDD.n577 VDD.n576 185
R625 VDD.n576 VDD.n575 185
R626 VDD.n531 VDD.n530 185
R627 VDD.n574 VDD.n531 185
R628 VDD.n572 VDD.n571 185
R629 VDD.n573 VDD.n572 185
R630 VDD.n570 VDD.n536 185
R631 VDD.n536 VDD.n535 185
R632 VDD.n569 VDD.n568 185
R633 VDD.n568 VDD.n567 185
R634 VDD.n538 VDD.n537 185
R635 VDD.n566 VDD.n538 185
R636 VDD.n564 VDD.n563 185
R637 VDD.n565 VDD.n564 185
R638 VDD.n63 VDD.n62 185
R639 VDD.n62 VDD.n52 185
R640 VDD.n18 VDD.n1 185
R641 VDD.n18 VDD.n16 185
R642 VDD.n700 VDD.n699 185
R643 VDD.n701 VDD.n700 185
R644 VDD.n698 VDD.n17 185
R645 VDD.n17 VDD.n15 185
R646 VDD.n697 VDD.n696 185
R647 VDD.n696 VDD.n695 185
R648 VDD.n20 VDD.n19 185
R649 VDD.n21 VDD.n20 185
R650 VDD.n688 VDD.n687 185
R651 VDD.n689 VDD.n688 185
R652 VDD.n686 VDD.n26 185
R653 VDD.n26 VDD.n25 185
R654 VDD.n685 VDD.n684 185
R655 VDD.n684 VDD.n683 185
R656 VDD.n28 VDD.n27 185
R657 VDD.n29 VDD.n28 185
R658 VDD.n676 VDD.n675 185
R659 VDD.n677 VDD.n676 185
R660 VDD.n674 VDD.n33 185
R661 VDD.n670 VDD.n33 185
R662 VDD.n673 VDD.n672 185
R663 VDD.n672 VDD.n671 185
R664 VDD.n35 VDD.n34 185
R665 VDD.n36 VDD.n35 185
R666 VDD.n663 VDD.n662 185
R667 VDD.n664 VDD.n663 185
R668 VDD.n661 VDD.n41 185
R669 VDD.n41 VDD.n40 185
R670 VDD.n660 VDD.n659 185
R671 VDD.n659 VDD.n658 185
R672 VDD.n43 VDD.n42 185
R673 VDD.n44 VDD.n43 185
R674 VDD.n651 VDD.n650 185
R675 VDD.n652 VDD.n651 185
R676 VDD.n649 VDD.n49 185
R677 VDD.n49 VDD.n48 185
R678 VDD.n648 VDD.n647 185
R679 VDD.n51 VDD.n50 185
R680 VDD.n644 VDD.n643 185
R681 VDD.n645 VDD.n644 185
R682 VDD.n642 VDD.n623 185
R683 VDD.n641 VDD.n640 185
R684 VDD.n639 VDD.n638 185
R685 VDD.n637 VDD.n636 185
R686 VDD.n635 VDD.n634 185
R687 VDD.n633 VDD.n632 185
R688 VDD.n631 VDD.n630 185
R689 VDD.n629 VDD.n628 185
R690 VDD.n627 VDD.n626 185
R691 VDD.n625 VDD.n624 185
R692 VDD.n704 VDD.n12 185
R693 VDD.n16 VDD.n12 185
R694 VDD.n703 VDD.n702 185
R695 VDD.n702 VDD.n701 185
R696 VDD.n14 VDD.n13 185
R697 VDD.n15 VDD.n14 185
R698 VDD.n694 VDD.n693 185
R699 VDD.n695 VDD.n694 185
R700 VDD.n692 VDD.n22 185
R701 VDD.n22 VDD.n21 185
R702 VDD.n691 VDD.n690 185
R703 VDD.n690 VDD.n689 185
R704 VDD.n24 VDD.n23 185
R705 VDD.n25 VDD.n24 185
R706 VDD.n682 VDD.n681 185
R707 VDD.n683 VDD.n682 185
R708 VDD.n680 VDD.n30 185
R709 VDD.n30 VDD.n29 185
R710 VDD.n679 VDD.n678 185
R711 VDD.n678 VDD.n677 185
R712 VDD.n32 VDD.n31 185
R713 VDD.n670 VDD.n32 185
R714 VDD.n669 VDD.n668 185
R715 VDD.n671 VDD.n669 185
R716 VDD.n667 VDD.n37 185
R717 VDD.n37 VDD.n36 185
R718 VDD.n666 VDD.n665 185
R719 VDD.n665 VDD.n664 185
R720 VDD.n39 VDD.n38 185
R721 VDD.n40 VDD.n39 185
R722 VDD.n657 VDD.n656 185
R723 VDD.n658 VDD.n657 185
R724 VDD.n655 VDD.n45 185
R725 VDD.n45 VDD.n44 185
R726 VDD.n654 VDD.n653 185
R727 VDD.n653 VDD.n652 185
R728 VDD.n47 VDD.n46 185
R729 VDD.n48 VDD.n47 185
R730 VDD.n706 VDD.n705 185
R731 VDD.n708 VDD.n10 185
R732 VDD.n710 VDD.n709 185
R733 VDD.n711 VDD.n9 185
R734 VDD.n713 VDD.n712 185
R735 VDD.n715 VDD.n7 185
R736 VDD.n717 VDD.n716 185
R737 VDD.n718 VDD.n6 185
R738 VDD.n720 VDD.n719 185
R739 VDD.n722 VDD.n5 185
R740 VDD.n723 VDD.n2 185
R741 VDD.n4 VDD.n3 185
R742 VDD.n645 VDD.n617 167.416
R743 VDD.n218 VDD.n216 150.651
R744 VDD.n218 VDD.n217 150.651
R745 VDD.n388 VDD.n228 146.368
R746 VDD.n647 VDD.n49 146.341
R747 VDD.n18 VDD.n3 146.341
R748 VDD.n624 VDD.n47 146.341
R749 VDD.n706 VDD.n12 146.341
R750 VDD.n593 VDD.n83 112.165
R751 VDD.n651 VDD.n49 105.367
R752 VDD.n651 VDD.n43 105.367
R753 VDD.n659 VDD.n43 105.367
R754 VDD.n659 VDD.n41 105.367
R755 VDD.n663 VDD.n41 105.367
R756 VDD.n663 VDD.n35 105.367
R757 VDD.n672 VDD.n35 105.367
R758 VDD.n672 VDD.n33 105.367
R759 VDD.n676 VDD.n33 105.367
R760 VDD.n676 VDD.n28 105.367
R761 VDD.n684 VDD.n28 105.367
R762 VDD.n684 VDD.n26 105.367
R763 VDD.n688 VDD.n26 105.367
R764 VDD.n688 VDD.n20 105.367
R765 VDD.n696 VDD.n20 105.367
R766 VDD.n696 VDD.n17 105.367
R767 VDD.n700 VDD.n17 105.367
R768 VDD.n700 VDD.n18 105.367
R769 VDD.n644 VDD.n51 105.367
R770 VDD.n644 VDD.n623 105.367
R771 VDD.n640 VDD.n639 105.367
R772 VDD.n636 VDD.n635 105.367
R773 VDD.n632 VDD.n631 105.367
R774 VDD.n628 VDD.n627 105.367
R775 VDD.n653 VDD.n47 105.367
R776 VDD.n653 VDD.n45 105.367
R777 VDD.n657 VDD.n45 105.367
R778 VDD.n657 VDD.n39 105.367
R779 VDD.n665 VDD.n39 105.367
R780 VDD.n665 VDD.n37 105.367
R781 VDD.n669 VDD.n37 105.367
R782 VDD.n669 VDD.n32 105.367
R783 VDD.n678 VDD.n32 105.367
R784 VDD.n678 VDD.n30 105.367
R785 VDD.n682 VDD.n30 105.367
R786 VDD.n682 VDD.n24 105.367
R787 VDD.n690 VDD.n24 105.367
R788 VDD.n690 VDD.n22 105.367
R789 VDD.n694 VDD.n22 105.367
R790 VDD.n694 VDD.n14 105.367
R791 VDD.n702 VDD.n14 105.367
R792 VDD.n702 VDD.n12 105.367
R793 VDD.n723 VDD.n722 105.367
R794 VDD.n720 VDD.n6 105.367
R795 VDD.n716 VDD.n715 105.367
R796 VDD.n713 VDD.n9 105.367
R797 VDD.n709 VDD.n708 105.367
R798 VDD.n725 VDD.n724 82.0128
R799 VDD.n194 VDD.n193 75.3262
R800 VDD.n195 VDD.n191 75.3262
R801 VDD.n202 VDD.n201 75.3262
R802 VDD.n203 VDD.n189 75.3262
R803 VDD.n210 VDD.n209 75.3262
R804 VDD.n214 VDD.n187 75.3262
R805 VDD.n217 VDD.n185 75.3262
R806 VDD.n485 VDD.n484 75.3262
R807 VDD.n616 VDD.n615 75.3262
R808 VDD.n610 VDD.n53 75.3262
R809 VDD.n607 VDD.n54 75.3262
R810 VDD.n603 VDD.n55 75.3262
R811 VDD.n599 VDD.n56 75.3262
R812 VDD.n551 VDD.n57 75.3262
R813 VDD.n555 VDD.n58 75.3262
R814 VDD.n616 VDD.n61 75.3262
R815 VDD.n608 VDD.n53 75.3262
R816 VDD.n604 VDD.n54 75.3262
R817 VDD.n600 VDD.n55 75.3262
R818 VDD.n550 VDD.n56 75.3262
R819 VDD.n554 VDD.n57 75.3262
R820 VDD.n557 VDD.n58 75.3262
R821 VDD.n485 VDD.n131 75.3262
R822 VDD.n216 VDD.n215 75.3262
R823 VDD.n211 VDD.n187 75.3262
R824 VDD.n209 VDD.n208 75.3262
R825 VDD.n204 VDD.n203 75.3262
R826 VDD.n201 VDD.n200 75.3262
R827 VDD.n196 VDD.n195 75.3262
R828 VDD.n193 VDD.n183 75.3262
R829 VDD.n646 VDD.n645 71.9982
R830 VDD.n645 VDD.n618 71.9982
R831 VDD.n645 VDD.n619 71.9982
R832 VDD.n645 VDD.n620 71.9982
R833 VDD.n645 VDD.n621 71.9982
R834 VDD.n645 VDD.n622 71.9982
R835 VDD.n707 VDD.n4 71.9982
R836 VDD.n11 VDD.n4 71.9982
R837 VDD.n714 VDD.n4 71.9982
R838 VDD.n8 VDD.n4 71.9982
R839 VDD.n721 VDD.n4 71.9982
R840 VDD.n724 VDD.n4 71.9982
R841 VDD.n726 VDD.n725 71.9982
R842 VDD.n403 VDD.n402 63.2476
R843 VDD.n407 VDD.n182 63.2476
R844 VDD.n614 VDD.n63 63.2476
R845 VDD.n560 VDD.n559 63.2476
R846 VDD.n617 VDD.n616 54.8384
R847 VDD.n617 VDD.n53 54.8384
R848 VDD.n617 VDD.n54 54.8384
R849 VDD.n617 VDD.n55 54.8384
R850 VDD.n617 VDD.n56 54.8384
R851 VDD.n617 VDD.n57 54.8384
R852 VDD.n617 VDD.n58 54.8384
R853 VDD.n486 VDD.n485 54.8384
R854 VDD.n217 VDD.n184 54.8384
R855 VDD.n401 VDD.n218 54.8384
R856 VDD.n216 VDD.n184 54.8384
R857 VDD.n187 VDD.n184 54.8384
R858 VDD.n209 VDD.n184 54.8384
R859 VDD.n203 VDD.n184 54.8384
R860 VDD.n201 VDD.n184 54.8384
R861 VDD.n195 VDD.n184 54.8384
R862 VDD.n193 VDD.n184 54.8384
R863 VDD.n405 VDD.n184 52.523
R864 VDD.n617 VDD.n52 52.523
R865 VDD.n405 VDD.n180 47.2707
R866 VDD.n411 VDD.n180 47.2707
R867 VDD.n417 VDD.n176 47.2707
R868 VDD.n417 VDD.n172 47.2707
R869 VDD.n423 VDD.n172 47.2707
R870 VDD.n429 VDD.n168 47.2707
R871 VDD.n429 VDD.n164 47.2707
R872 VDD.n435 VDD.n164 47.2707
R873 VDD.n441 VDD.n160 47.2707
R874 VDD.n441 VDD.n155 47.2707
R875 VDD.n447 VDD.n155 47.2707
R876 VDD.n447 VDD.n156 47.2707
R877 VDD.n453 VDD.n147 47.2707
R878 VDD.n459 VDD.n147 47.2707
R879 VDD.n459 VDD.n148 47.2707
R880 VDD.n467 VDD.n139 47.2707
R881 VDD.n473 VDD.n139 47.2707
R882 VDD.n474 VDD.n473 47.2707
R883 VDD.n477 VDD.n132 47.2707
R884 VDD.n483 VDD.n132 47.2707
R885 VDD.n483 VDD.n133 47.2707
R886 VDD.n490 VDD.n123 47.2707
R887 VDD.n496 VDD.n123 47.2707
R888 VDD.n496 VDD.n124 47.2707
R889 VDD.n502 VDD.n115 47.2707
R890 VDD.n508 VDD.n115 47.2707
R891 VDD.n508 VDD.n116 47.2707
R892 VDD.n514 VDD.n107 47.2707
R893 VDD.n520 VDD.n107 47.2707
R894 VDD.n520 VDD.n103 47.2707
R895 VDD.n526 VDD.n103 47.2707
R896 VDD.n581 VDD.n97 47.2707
R897 VDD.n581 VDD.n98 47.2707
R898 VDD.n575 VDD.n98 47.2707
R899 VDD.n574 VDD.n573 47.2707
R900 VDD.n573 VDD.n535 47.2707
R901 VDD.n567 VDD.n535 47.2707
R902 VDD.n566 VDD.n565 47.2707
R903 VDD.n565 VDD.n52 47.2707
R904 VDD.n652 VDD.n48 47.2707
R905 VDD.n652 VDD.n44 47.2707
R906 VDD.n658 VDD.n44 47.2707
R907 VDD.n658 VDD.n40 47.2707
R908 VDD.n664 VDD.n40 47.2707
R909 VDD.n664 VDD.n36 47.2707
R910 VDD.n671 VDD.n36 47.2707
R911 VDD.n671 VDD.n670 47.2707
R912 VDD.n677 VDD.n29 47.2707
R913 VDD.n683 VDD.n29 47.2707
R914 VDD.n683 VDD.n25 47.2707
R915 VDD.n689 VDD.n25 47.2707
R916 VDD.n689 VDD.n21 47.2707
R917 VDD.n695 VDD.n21 47.2707
R918 VDD.n695 VDD.n15 47.2707
R919 VDD.n701 VDD.n15 47.2707
R920 VDD.n701 VDD.n16 47.2707
R921 VDD.n670 VDD.t24 46.6142
R922 VDD.n435 VDD.t12 43.3315
R923 VDD.n453 VDD.t16 43.3315
R924 VDD.n116 VDD.t2 43.3315
R925 VDD.t0 VDD.n97 43.3315
R926 VDD.n647 VDD.n646 41.0066
R927 VDD.n623 VDD.n618 41.0066
R928 VDD.n639 VDD.n619 41.0066
R929 VDD.n635 VDD.n620 41.0066
R930 VDD.n631 VDD.n621 41.0066
R931 VDD.n627 VDD.n622 41.0066
R932 VDD.n646 VDD.n51 41.0066
R933 VDD.n640 VDD.n618 41.0066
R934 VDD.n636 VDD.n619 41.0066
R935 VDD.n632 VDD.n620 41.0066
R936 VDD.n628 VDD.n621 41.0066
R937 VDD.n624 VDD.n622 41.0066
R938 VDD.n724 VDD.n723 41.0066
R939 VDD.n721 VDD.n720 41.0066
R940 VDD.n716 VDD.n8 41.0066
R941 VDD.n714 VDD.n713 41.0066
R942 VDD.n709 VDD.n11 41.0066
R943 VDD.n707 VDD.n706 41.0066
R944 VDD.n708 VDD.n707 41.0066
R945 VDD.n11 VDD.n9 41.0066
R946 VDD.n715 VDD.n714 41.0066
R947 VDD.n8 VDD.n6 41.0066
R948 VDD.n722 VDD.n721 41.0066
R949 VDD.n725 VDD.n3 41.0066
R950 VDD.n423 VDD.t8 35.4532
R951 VDD.n467 VDD.t18 35.4532
R952 VDD.n124 VDD.t10 35.4532
R953 VDD.t22 VDD.n574 35.4532
R954 VDD.n390 VDD.n228 32.0232
R955 VDD.n584 VDD.n583 28.6405
R956 VDD.n510 VDD.n113 28.6405
R957 VDD.n486 VDD.n130 28.6405
R958 VDD.n279 VDD.n145 28.6405
R959 VDD.n411 VDD.t4 27.5748
R960 VDD.n477 VDD.t14 27.5748
R961 VDD.n133 VDD.t6 27.5748
R962 VDD.t20 VDD.n566 27.5748
R963 VDD.n402 VDD.n401 27.1064
R964 VDD.n403 VDD.n178 27.1064
R965 VDD.n413 VDD.n178 27.1064
R966 VDD.n414 VDD.n413 27.1064
R967 VDD.n415 VDD.n414 27.1064
R968 VDD.n415 VDD.n170 27.1064
R969 VDD.n425 VDD.n170 27.1064
R970 VDD.n426 VDD.n425 27.1064
R971 VDD.n427 VDD.n426 27.1064
R972 VDD.n427 VDD.n162 27.1064
R973 VDD.n437 VDD.n162 27.1064
R974 VDD.n438 VDD.n437 27.1064
R975 VDD.n439 VDD.n438 27.1064
R976 VDD.n439 VDD.n153 27.1064
R977 VDD.n449 VDD.n153 27.1064
R978 VDD.n450 VDD.n449 27.1064
R979 VDD.n451 VDD.n450 27.1064
R980 VDD.n462 VDD.n461 27.1064
R981 VDD.n465 VDD.n462 27.1064
R982 VDD.n465 VDD.n464 27.1064
R983 VDD.n464 VDD.n463 27.1064
R984 VDD.n463 VDD.n138 27.1064
R985 VDD.n138 VDD.n129 27.1064
R986 VDD.n488 VDD.n487 27.1064
R987 VDD.n488 VDD.n121 27.1064
R988 VDD.n498 VDD.n121 27.1064
R989 VDD.n499 VDD.n498 27.1064
R990 VDD.n500 VDD.n499 27.1064
R991 VDD.n500 VDD.n112 27.1064
R992 VDD.n512 VDD.n511 27.1064
R993 VDD.n512 VDD.n105 27.1064
R994 VDD.n522 VDD.n105 27.1064
R995 VDD.n523 VDD.n522 27.1064
R996 VDD.n524 VDD.n523 27.1064
R997 VDD.n524 VDD.n93 27.1064
R998 VDD.n192 VDD.n182 27.1064
R999 VDD.n197 VDD.n192 27.1064
R1000 VDD.n198 VDD.n197 27.1064
R1001 VDD.n199 VDD.n198 27.1064
R1002 VDD.n199 VDD.n190 27.1064
R1003 VDD.n205 VDD.n190 27.1064
R1004 VDD.n206 VDD.n205 27.1064
R1005 VDD.n207 VDD.n206 27.1064
R1006 VDD.n207 VDD.n188 27.1064
R1007 VDD.n212 VDD.n188 27.1064
R1008 VDD.n213 VDD.n212 27.1064
R1009 VDD.n213 VDD.n186 27.1064
R1010 VDD.n408 VDD.n407 27.1064
R1011 VDD.n409 VDD.n408 27.1064
R1012 VDD.n409 VDD.n174 27.1064
R1013 VDD.n419 VDD.n174 27.1064
R1014 VDD.n420 VDD.n419 27.1064
R1015 VDD.n421 VDD.n420 27.1064
R1016 VDD.n421 VDD.n166 27.1064
R1017 VDD.n431 VDD.n166 27.1064
R1018 VDD.n432 VDD.n431 27.1064
R1019 VDD.n433 VDD.n432 27.1064
R1020 VDD.n433 VDD.n158 27.1064
R1021 VDD.n443 VDD.n158 27.1064
R1022 VDD.n444 VDD.n443 27.1064
R1023 VDD.n445 VDD.n444 27.1064
R1024 VDD.n445 VDD.n150 27.1064
R1025 VDD.n455 VDD.n150 27.1064
R1026 VDD.n456 VDD.n455 27.1064
R1027 VDD.n457 VDD.n456 27.1064
R1028 VDD.n457 VDD.n141 27.1064
R1029 VDD.n469 VDD.n141 27.1064
R1030 VDD.n470 VDD.n469 27.1064
R1031 VDD.n471 VDD.n470 27.1064
R1032 VDD.n471 VDD.n135 27.1064
R1033 VDD.n479 VDD.n135 27.1064
R1034 VDD.n480 VDD.n479 27.1064
R1035 VDD.n481 VDD.n480 27.1064
R1036 VDD.n481 VDD.n126 27.1064
R1037 VDD.n492 VDD.n126 27.1064
R1038 VDD.n493 VDD.n492 27.1064
R1039 VDD.n494 VDD.n493 27.1064
R1040 VDD.n494 VDD.n118 27.1064
R1041 VDD.n504 VDD.n118 27.1064
R1042 VDD.n505 VDD.n504 27.1064
R1043 VDD.n506 VDD.n505 27.1064
R1044 VDD.n506 VDD.n109 27.1064
R1045 VDD.n516 VDD.n109 27.1064
R1046 VDD.n517 VDD.n516 27.1064
R1047 VDD.n518 VDD.n517 27.1064
R1048 VDD.n518 VDD.n101 27.1064
R1049 VDD.n528 VDD.n101 27.1064
R1050 VDD.n529 VDD.n528 27.1064
R1051 VDD.n579 VDD.n529 27.1064
R1052 VDD.n579 VDD.n578 27.1064
R1053 VDD.n578 VDD.n577 27.1064
R1054 VDD.n577 VDD.n530 27.1064
R1055 VDD.n571 VDD.n530 27.1064
R1056 VDD.n571 VDD.n570 27.1064
R1057 VDD.n570 VDD.n569 27.1064
R1058 VDD.n569 VDD.n537 27.1064
R1059 VDD.n563 VDD.n537 27.1064
R1060 VDD.n563 VDD.n63 27.1064
R1061 VDD.n542 VDD.n94 27.1064
R1062 VDD.n543 VDD.n542 27.1064
R1063 VDD.n544 VDD.n543 27.1064
R1064 VDD.n546 VDD.n544 27.1064
R1065 VDD.n547 VDD.n546 27.1064
R1066 VDD.n548 VDD.n547 27.1064
R1067 VDD.n561 VDD.n548 27.1064
R1068 VDD.n561 VDD.n560 27.1064
R1069 VDD.n549 VDD.n64 27.1064
R1070 VDD.n552 VDD.n549 27.1064
R1071 VDD.n553 VDD.n552 27.1064
R1072 VDD.n556 VDD.n553 27.1064
R1073 VDD.n558 VDD.n556 27.1064
R1074 VDD.n559 VDD.n558 27.1064
R1075 VDD.n365 VDD.n364 27.1064
R1076 VDD.n362 VDD.n361 27.1064
R1077 VDD.n358 VDD.n357 27.1064
R1078 VDD.n354 VDD.n353 27.1064
R1079 VDD.n588 VDD.n587 27.1064
R1080 VDD.n347 VDD.n322 27.1064
R1081 VDD.n342 VDD.n323 27.1064
R1082 VDD.n338 VDD.n327 27.1064
R1083 VDD.n336 VDD.n335 27.1064
R1084 VDD.n331 VDD.n330 27.1064
R1085 VDD.n315 VDD.n289 27.1064
R1086 VDD.n310 VDD.n290 27.1064
R1087 VDD.n306 VDD.n294 27.1064
R1088 VDD.n304 VDD.n303 27.1064
R1089 VDD.n298 VDD.n297 27.1064
R1090 VDD.n282 VDD.n256 27.1064
R1091 VDD.n263 VDD.n257 27.1064
R1092 VDD.n267 VDD.n266 27.1064
R1093 VDD.n271 VDD.n270 27.1064
R1094 VDD.n276 VDD.n275 27.1064
R1095 VDD.n249 VDD.n248 27.1064
R1096 VDD.n246 VDD.n245 27.1064
R1097 VDD.n242 VDD.n241 27.1064
R1098 VDD.n238 VDD.n225 27.1064
R1099 VDD.n396 VDD.n220 27.1064
R1100 VDD.n595 VDD.n594 27.1064
R1101 VDD.n77 VDD.n76 27.1064
R1102 VDD.n81 VDD.n71 27.1064
R1103 VDD.n614 VDD.n613 27.1064
R1104 VDD.n613 VDD.n612 27.1064
R1105 VDD.n612 VDD.n611 27.1064
R1106 VDD.n611 VDD.n609 27.1064
R1107 VDD.n609 VDD.n606 27.1064
R1108 VDD.n606 VDD.n605 27.1064
R1109 VDD.n605 VDD.n602 27.1064
R1110 VDD.n387 VDD.n234 27.1064
R1111 VDD.n381 VDD.n374 27.1064
R1112 VDD.n379 VDD.n378 27.1064
R1113 VDD.n375 VDD.n230 27.1064
R1114 VDD.n486 VDD.n129 26.3534
R1115 VDD.n487 VDD.n486 24.8476
R1116 VDD.n594 VDD.n593 24.5406
R1117 VDD.n401 VDD.n186 24.0946
R1118 VDD.n351 VDD.n92 22.6011
R1119 VDD.n344 VDD.n319 22.6011
R1120 VDD.n312 VDD.n286 22.6011
R1121 VDD.n262 VDD.n253 22.6011
R1122 VDD.n236 VDD.n221 22.6011
R1123 VDD.n74 VDD.n69 22.6011
R1124 VDD.n401 VDD.n400 21.7605
R1125 VDD.n601 VDD.n598 21.7605
R1126 VDD.t4 VDD.n176 19.6964
R1127 VDD.n474 VDD.t14 19.6964
R1128 VDD.n490 VDD.t6 19.6964
R1129 VDD.n567 VDD.t20 19.6964
R1130 VDD.n586 VDD.n88 18.4075
R1131 VDD.n328 VDD.n324 18.4075
R1132 VDD.n278 VDD.n258 18.4075
R1133 VDD.n295 VDD.n291 17.9607
R1134 VDD.n727 VDD.n726 17.0245
R1135 VDD.n451 VDD.n145 16.5652
R1136 VDD.n511 VDD.n510 16.5652
R1137 VDD.n583 VDD.n93 16.5652
R1138 VDD.n399 VDD.n220 16.1096
R1139 VDD.n705 VDD.n704 15.6103
R1140 VDD.n625 VDD.n46 15.6103
R1141 VDD.n649 VDD.n648 15.6103
R1142 VDD.n726 VDD.n1 15.4542
R1143 VDD.n364 VDD.n92 13.2471
R1144 VDD.n362 VDD.n91 13.2471
R1145 VDD.n358 VDD.n90 13.2471
R1146 VDD.n354 VDD.n89 13.2471
R1147 VDD.n588 VDD.n87 13.2471
R1148 VDD.n365 VDD.n91 13.2471
R1149 VDD.n361 VDD.n90 13.2471
R1150 VDD.n357 VDD.n89 13.2471
R1151 VDD.n353 VDD.n87 13.2471
R1152 VDD.n587 VDD.n586 13.2471
R1153 VDD.n344 VDD.n322 13.2471
R1154 VDD.n346 VDD.n323 13.2471
R1155 VDD.n343 VDD.n327 13.2471
R1156 VDD.n336 VDD.n326 13.2471
R1157 VDD.n331 VDD.n325 13.2471
R1158 VDD.n347 VDD.n346 13.2471
R1159 VDD.n343 VDD.n342 13.2471
R1160 VDD.n338 VDD.n326 13.2471
R1161 VDD.n335 VDD.n325 13.2471
R1162 VDD.n330 VDD.n324 13.2471
R1163 VDD.n312 VDD.n289 13.2471
R1164 VDD.n314 VDD.n290 13.2471
R1165 VDD.n311 VDD.n294 13.2471
R1166 VDD.n304 VDD.n293 13.2471
R1167 VDD.n298 VDD.n292 13.2471
R1168 VDD.n315 VDD.n314 13.2471
R1169 VDD.n311 VDD.n310 13.2471
R1170 VDD.n306 VDD.n293 13.2471
R1171 VDD.n303 VDD.n292 13.2471
R1172 VDD.n297 VDD.n291 13.2471
R1173 VDD.n262 VDD.n256 13.2471
R1174 VDD.n281 VDD.n257 13.2471
R1175 VDD.n266 VDD.n261 13.2471
R1176 VDD.n270 VDD.n260 13.2471
R1177 VDD.n275 VDD.n259 13.2471
R1178 VDD.n282 VDD.n281 13.2471
R1179 VDD.n263 VDD.n261 13.2471
R1180 VDD.n267 VDD.n260 13.2471
R1181 VDD.n271 VDD.n259 13.2471
R1182 VDD.n276 VDD.n258 13.2471
R1183 VDD.n249 VDD.n222 13.2471
R1184 VDD.n245 VDD.n223 13.2471
R1185 VDD.n241 VDD.n224 13.2471
R1186 VDD.n397 VDD.n225 13.2471
R1187 VDD.n248 VDD.n221 13.2471
R1188 VDD.n246 VDD.n222 13.2471
R1189 VDD.n242 VDD.n223 13.2471
R1190 VDD.n238 VDD.n224 13.2471
R1191 VDD.n397 VDD.n396 13.2471
R1192 VDD.n77 VDD.n70 13.2471
R1193 VDD.n82 VDD.n81 13.2471
R1194 VDD.n76 VDD.n69 13.2471
R1195 VDD.n71 VDD.n70 13.2471
R1196 VDD.n82 VDD.n65 13.2471
R1197 VDD.n374 VDD.n233 13.2471
R1198 VDD.n379 VDD.n232 13.2471
R1199 VDD.n375 VDD.n231 13.2471
R1200 VDD.n390 VDD.n389 13.2471
R1201 VDD.n234 VDD.n233 13.2471
R1202 VDD.n381 VDD.n232 13.2471
R1203 VDD.n378 VDD.n231 13.2471
R1204 VDD.n389 VDD.n230 13.2471
R1205 VDD.n601 VDD.n64 12.8005
R1206 VDD.n598 VDD.n65 12.0476
R1207 VDD.t8 VDD.n168 11.8181
R1208 VDD.n148 VDD.t18 11.8181
R1209 VDD.n502 VDD.t10 11.8181
R1210 VDD.n575 VDD.t22 11.8181
R1211 VDD.n602 VDD.n601 11.2946
R1212 VDD.n5 VDD.n2 11.2395
R1213 VDD.n719 VDD.n5 11.2395
R1214 VDD.n719 VDD.n718 11.2395
R1215 VDD.n718 VDD.n717 11.2395
R1216 VDD.n717 VDD.n7 11.2395
R1217 VDD.n712 VDD.n7 11.2395
R1218 VDD.n712 VDD.n711 11.2395
R1219 VDD.n711 VDD.n710 11.2395
R1220 VDD.n710 VDD.n10 11.2395
R1221 VDD.n705 VDD.n10 11.2395
R1222 VDD.n654 VDD.n46 11.2395
R1223 VDD.n655 VDD.n654 11.2395
R1224 VDD.n656 VDD.n655 11.2395
R1225 VDD.n656 VDD.n38 11.2395
R1226 VDD.n666 VDD.n38 11.2395
R1227 VDD.n667 VDD.n666 11.2395
R1228 VDD.n668 VDD.n667 11.2395
R1229 VDD.n668 VDD.n31 11.2395
R1230 VDD.n679 VDD.n31 11.2395
R1231 VDD.n680 VDD.n679 11.2395
R1232 VDD.n681 VDD.n680 11.2395
R1233 VDD.n681 VDD.n23 11.2395
R1234 VDD.n691 VDD.n23 11.2395
R1235 VDD.n692 VDD.n691 11.2395
R1236 VDD.n693 VDD.n692 11.2395
R1237 VDD.n693 VDD.n13 11.2395
R1238 VDD.n703 VDD.n13 11.2395
R1239 VDD.n704 VDD.n703 11.2395
R1240 VDD.n648 VDD.n50 11.2395
R1241 VDD.n643 VDD.n50 11.2395
R1242 VDD.n643 VDD.n642 11.2395
R1243 VDD.n642 VDD.n641 11.2395
R1244 VDD.n641 VDD.n638 11.2395
R1245 VDD.n638 VDD.n637 11.2395
R1246 VDD.n637 VDD.n634 11.2395
R1247 VDD.n634 VDD.n633 11.2395
R1248 VDD.n633 VDD.n630 11.2395
R1249 VDD.n630 VDD.n629 11.2395
R1250 VDD.n629 VDD.n626 11.2395
R1251 VDD.n626 VDD.n625 11.2395
R1252 VDD.n650 VDD.n649 11.2395
R1253 VDD.n650 VDD.n42 11.2395
R1254 VDD.n660 VDD.n42 11.2395
R1255 VDD.n661 VDD.n660 11.2395
R1256 VDD.n662 VDD.n661 11.2395
R1257 VDD.n662 VDD.n34 11.2395
R1258 VDD.n673 VDD.n34 11.2395
R1259 VDD.n674 VDD.n673 11.2395
R1260 VDD.n675 VDD.n674 11.2395
R1261 VDD.n675 VDD.n27 11.2395
R1262 VDD.n685 VDD.n27 11.2395
R1263 VDD.n686 VDD.n685 11.2395
R1264 VDD.n687 VDD.n686 11.2395
R1265 VDD.n687 VDD.n19 11.2395
R1266 VDD.n697 VDD.n19 11.2395
R1267 VDD.n698 VDD.n697 11.2395
R1268 VDD.n699 VDD.n698 11.2395
R1269 VDD.n699 VDD.n1 11.2395
R1270 VDD.n585 VDD.t1 9.8505
R1271 VDD.n585 VDD.t23 9.8505
R1272 VDD.n345 VDD.t11 9.8505
R1273 VDD.n345 VDD.t3 9.8505
R1274 VDD.n313 VDD.t15 9.8505
R1275 VDD.n313 VDD.t7 9.8505
R1276 VDD.n280 VDD.t17 9.8505
R1277 VDD.n280 VDD.t19 9.8505
R1278 VDD.n388 VDD.t9 9.8505
R1279 VDD.n388 VDD.t13 9.8505
R1280 VDD.n387 VDD.n386 9.35455
R1281 VDD.n364 VDD.n352 9.3005
R1282 VDD.n366 VDD.n365 9.3005
R1283 VDD.n363 VDD.n362 9.3005
R1284 VDD.n361 VDD.n360 9.3005
R1285 VDD.n359 VDD.n358 9.3005
R1286 VDD.n357 VDD.n356 9.3005
R1287 VDD.n355 VDD.n354 9.3005
R1288 VDD.n587 VDD.n86 9.3005
R1289 VDD.n353 VDD.n85 9.3005
R1290 VDD.n589 VDD.n588 9.3005
R1291 VDD.n322 VDD.n320 9.3005
R1292 VDD.n348 VDD.n347 9.3005
R1293 VDD.n323 VDD.n321 9.3005
R1294 VDD.n342 VDD.n341 9.3005
R1295 VDD.n340 VDD.n327 9.3005
R1296 VDD.n339 VDD.n338 9.3005
R1297 VDD.n337 VDD.n336 9.3005
R1298 VDD.n330 VDD.n329 9.3005
R1299 VDD.n335 VDD.n334 9.3005
R1300 VDD.n332 VDD.n331 9.3005
R1301 VDD.n289 VDD.n287 9.3005
R1302 VDD.n316 VDD.n315 9.3005
R1303 VDD.n290 VDD.n288 9.3005
R1304 VDD.n310 VDD.n309 9.3005
R1305 VDD.n308 VDD.n294 9.3005
R1306 VDD.n307 VDD.n306 9.3005
R1307 VDD.n305 VDD.n304 9.3005
R1308 VDD.n297 VDD.n296 9.3005
R1309 VDD.n303 VDD.n302 9.3005
R1310 VDD.n299 VDD.n298 9.3005
R1311 VDD.n256 VDD.n254 9.3005
R1312 VDD.n283 VDD.n282 9.3005
R1313 VDD.n257 VDD.n255 9.3005
R1314 VDD.n264 VDD.n263 9.3005
R1315 VDD.n266 VDD.n265 9.3005
R1316 VDD.n268 VDD.n267 9.3005
R1317 VDD.n270 VDD.n269 9.3005
R1318 VDD.n277 VDD.n276 9.3005
R1319 VDD.n272 VDD.n271 9.3005
R1320 VDD.n275 VDD.n274 9.3005
R1321 VDD.n248 VDD.n237 9.3005
R1322 VDD.n250 VDD.n249 9.3005
R1323 VDD.n247 VDD.n246 9.3005
R1324 VDD.n245 VDD.n244 9.3005
R1325 VDD.n243 VDD.n242 9.3005
R1326 VDD.n241 VDD.n240 9.3005
R1327 VDD.n239 VDD.n238 9.3005
R1328 VDD.n220 VDD.n219 9.3005
R1329 VDD.n226 VDD.n225 9.3005
R1330 VDD.n396 VDD.n395 9.3005
R1331 VDD.n594 VDD.n68 9.3005
R1332 VDD.n596 VDD.n595 9.3005
R1333 VDD.n76 VDD.n75 9.3005
R1334 VDD.n78 VDD.n77 9.3005
R1335 VDD.n79 VDD.n71 9.3005
R1336 VDD.n81 VDD.n80 9.3005
R1337 VDD.n67 VDD.n65 9.3005
R1338 VDD.n598 VDD.n597 9.3005
R1339 VDD.n728 VDD.n727 9.3005
R1340 VDD.n235 VDD.n234 9.3005
R1341 VDD.n383 VDD.n374 9.3005
R1342 VDD.n391 VDD.n390 9.3005
R1343 VDD.n382 VDD.n381 9.3005
R1344 VDD.n380 VDD.n379 9.3005
R1345 VDD.n378 VDD.n377 9.3005
R1346 VDD.n376 VDD.n375 9.3005
R1347 VDD.n230 VDD.n229 9.3005
R1348 VDD.n645 VDD.n48 9.19193
R1349 VDD.n16 VDD.n4 9.19193
R1350 VDD.n728 VDD.n0 8.85683
R1351 VDD.n593 VDD.n592 8.55924
R1352 VDD.n400 VDD.n399 8.05529
R1353 VDD.n461 VDD.n145 7.52991
R1354 VDD.n510 VDD.n112 7.52991
R1355 VDD.n583 VDD.n94 7.52991
R1356 VDD.n726 VDD.n2 7.02489
R1357 VDD.n595 VDD.n66 5.96314
R1358 VDD.n598 VDD.n66 5.96314
R1359 VDD.n398 VDD.t5 5.9105
R1360 VDD.n83 VDD.t21 5.9105
R1361 VDD.n584 VDD.n88 5.2695
R1362 VDD.n328 VDD.n113 5.2695
R1363 VDD.n279 VDD.n278 5.2695
R1364 VDD.n400 VDD.n219 4.89556
R1365 VDD.n295 VDD.n130 4.81327
R1366 VDD.n368 VDD.n351 4.55421
R1367 VDD.n368 VDD.n367 4.55421
R1368 VDD.n350 VDD.n319 4.55421
R1369 VDD.n350 VDD.n349 4.55421
R1370 VDD.n318 VDD.n286 4.55421
R1371 VDD.n318 VDD.n317 4.55421
R1372 VDD.n285 VDD.n253 4.55421
R1373 VDD.n285 VDD.n284 4.55421
R1374 VDD.n252 VDD.n236 4.55421
R1375 VDD.n252 VDD.n251 4.55421
R1376 VDD.n74 VDD.n73 4.55421
R1377 VDD.n73 VDD.n72 4.55421
R1378 VDD.n386 VDD.n385 4.55421
R1379 VDD.n385 VDD.n384 4.55421
R1380 VDD.n394 VDD.n393 4.27888
R1381 VDD.n592 VDD.n591 4.27888
R1382 VDD.t12 VDD.n160 3.93968
R1383 VDD.n156 VDD.t16 3.93968
R1384 VDD.n514 VDD.t2 3.93968
R1385 VDD.n526 VDD.t0 3.93968
R1386 VDD.n591 VDD.n590 3.93696
R1387 VDD.n333 VDD.n84 3.93696
R1388 VDD.n301 VDD.n300 3.93696
R1389 VDD.n273 VDD.n227 3.93696
R1390 VDD.n393 VDD.n392 3.93696
R1391 VDD.n296 VDD.n295 2.51397
R1392 VDD.n392 VDD.n228 2.41891
R1393 VDD.n88 VDD.n86 2.28823
R1394 VDD.n329 VDD.n328 2.28823
R1395 VDD.n278 VDD.n277 2.28823
R1396 VDD.n373 VDD.n252 2.02808
R1397 VDD.n369 VDD.n368 1.68615
R1398 VDD.n370 VDD.n350 1.68615
R1399 VDD.n371 VDD.n318 1.68615
R1400 VDD.n372 VDD.n285 1.68615
R1401 VDD.n73 VDD.n0 1.68615
R1402 VDD.n385 VDD.n373 1.68615
R1403 VDD.n677 VDD.t24 0.657031
R1404 VDD.n393 VDD.n227 0.353
R1405 VDD.n300 VDD.n227 0.353
R1406 VDD.n300 VDD.n84 0.353
R1407 VDD.n373 VDD.n372 0.353
R1408 VDD.n372 VDD.n371 0.353
R1409 VDD.n371 VDD.n370 0.353
R1410 VDD.n591 VDD.n84 0.351825
R1411 VDD.n370 VDD.n369 0.351825
R1412 VDD.n369 VDD.n0 0.342425
R1413 VDD.n366 VDD.n363 0.196152
R1414 VDD.n363 VDD.n360 0.196152
R1415 VDD.n360 VDD.n359 0.196152
R1416 VDD.n359 VDD.n356 0.196152
R1417 VDD.n348 VDD.n321 0.196152
R1418 VDD.n341 VDD.n321 0.196152
R1419 VDD.n341 VDD.n340 0.196152
R1420 VDD.n340 VDD.n339 0.196152
R1421 VDD.n316 VDD.n288 0.196152
R1422 VDD.n309 VDD.n288 0.196152
R1423 VDD.n309 VDD.n308 0.196152
R1424 VDD.n308 VDD.n307 0.196152
R1425 VDD.n283 VDD.n255 0.196152
R1426 VDD.n264 VDD.n255 0.196152
R1427 VDD.n265 VDD.n264 0.196152
R1428 VDD.n268 VDD.n265 0.196152
R1429 VDD.n250 VDD.n247 0.196152
R1430 VDD.n247 VDD.n244 0.196152
R1431 VDD.n244 VDD.n243 0.196152
R1432 VDD.n243 VDD.n240 0.196152
R1433 VDD.n79 VDD.n78 0.196152
R1434 VDD.n80 VDD.n79 0.196152
R1435 VDD.n80 VDD.n67 0.196152
R1436 VDD.n597 VDD.n67 0.196152
R1437 VDD.n383 VDD.n382 0.196152
R1438 VDD.n382 VDD.n380 0.196152
R1439 VDD.n380 VDD.n377 0.196152
R1440 VDD.n377 VDD.n376 0.196152
R1441 VDD.n589 VDD.n86 0.151939
R1442 VDD.n332 VDD.n329 0.151939
R1443 VDD.n299 VDD.n296 0.151939
R1444 VDD.n277 VDD.n274 0.151939
R1445 VDD.n395 VDD.n219 0.151939
R1446 VDD.n356 VDD 0.149957
R1447 VDD VDD.n305 0.149957
R1448 VDD VDD.n239 0.149957
R1449 VDD.n597 VDD 0.149957
R1450 VDD VDD.n229 0.149957
R1451 VDD.n355 VDD.n85 0.149883
R1452 VDD.n337 VDD.n334 0.149883
R1453 VDD.n305 VDD.n302 0.149883
R1454 VDD.n272 VDD.n269 0.149883
R1455 VDD.n239 VDD.n226 0.149883
R1456 VDD.n596 VDD.n68 0.149883
R1457 VDD.n391 VDD.n229 0.149883
R1458 VDD VDD.n337 0.103761
R1459 VDD.n269 VDD 0.103761
R1460 VDD.n339 VDD 0.0928913
R1461 VDD VDD.n268 0.0928913
R1462 VDD.n367 VDD.n366 0.0815811
R1463 VDD.n349 VDD.n348 0.0815811
R1464 VDD.n317 VDD.n316 0.0815811
R1465 VDD.n284 VDD.n283 0.0815811
R1466 VDD.n251 VDD.n250 0.0815811
R1467 VDD.n78 VDD.n72 0.0815811
R1468 VDD.n384 VDD.n383 0.0815811
R1469 VDD.n352 VDD.n351 0.0680676
R1470 VDD.n320 VDD.n319 0.0680676
R1471 VDD.n287 VDD.n286 0.0680676
R1472 VDD.n254 VDD.n253 0.0680676
R1473 VDD.n237 VDD.n236 0.0680676
R1474 VDD.n75 VDD.n74 0.0680676
R1475 VDD.n386 VDD.n235 0.0680676
R1476 VDD.n590 VDD.n589 0.0628658
R1477 VDD.n333 VDD.n332 0.0628658
R1478 VDD.n301 VDD.n299 0.0628658
R1479 VDD.n274 VDD.n273 0.0628658
R1480 VDD.n395 VDD.n394 0.0628658
R1481 VDD.n590 VDD.n85 0.0594876
R1482 VDD.n334 VDD.n333 0.0594876
R1483 VDD.n302 VDD.n301 0.0594876
R1484 VDD.n273 VDD.n272 0.0594876
R1485 VDD.n394 VDD.n226 0.0594876
R1486 VDD.n592 VDD.n68 0.0594876
R1487 VDD.n392 VDD.n391 0.0594876
R1488 VDD VDD.n355 0.0466957
R1489 VDD.n307 VDD 0.0466957
R1490 VDD.n240 VDD 0.0466957
R1491 VDD VDD.n596 0.0466957
R1492 VDD.n376 VDD 0.0466957
R1493 VDD.n367 VDD.n352 0.0410405
R1494 VDD.n349 VDD.n320 0.0410405
R1495 VDD.n317 VDD.n287 0.0410405
R1496 VDD.n284 VDD.n254 0.0410405
R1497 VDD.n251 VDD.n237 0.0410405
R1498 VDD.n75 VDD.n72 0.0410405
R1499 VDD.n384 VDD.n235 0.0410405
R1500 VDD VDD.n728 0.009875
R1501 VSS.n855 VSS.n653 585.938
R1502 VSS.n451 VSS.n450 585
R1503 VSS.n452 VSS.n451 585
R1504 VSS.n449 VSS.n177 585
R1505 VSS.n415 VSS.n177 585
R1506 VSS.n448 VSS.n447 585
R1507 VSS.n447 VSS.n446 585
R1508 VSS.n179 VSS.n178 585
R1509 VSS.n418 VSS.n179 585
R1510 VSS.n283 VSS.n186 585
R1511 VSS.n438 VSS.n186 585
R1512 VSS.n285 VSS.n284 585
R1513 VSS.n285 VSS.n194 585
R1514 VSS.n412 VSS.n393 585
R1515 VSS.n393 VSS.n175 585
R1516 VSS.n417 VSS.n413 585
R1517 VSS.n417 VSS.n416 585
R1518 VSS.n421 VSS.n392 585
R1519 VSS.n421 VSS.n420 585
R1520 VSS.n423 VSS.n422 585
R1521 VSS.n422 VSS.n187 585
R1522 VSS.n424 VSS.n196 585
R1523 VSS.n196 VSS.n185 585
R1524 VSS.n426 VSS.n425 585
R1525 VSS.n427 VSS.n426 585
R1526 VSS.n411 VSS.n399 585
R1527 VSS.n487 VSS.n89 585
R1528 VSS.n638 VSS.n89 585
R1529 VSS.n486 VSS.n485 585
R1530 VSS.n485 VSS.n484 585
R1531 VSS.n115 VSS.n114 585
R1532 VSS.n116 VSS.n115 585
R1533 VSS.n462 VSS.n122 585
R1534 VSS.n474 VSS.n122 585
R1535 VSS.n463 VSS.n461 585
R1536 VSS.n461 VSS.n121 585
R1537 VSS.n465 VSS.n464 585
R1538 VSS.n467 VSS.n465 585
R1539 VSS.n184 VSS.n183 585
R1540 VSS.n194 VSS.n184 585
R1541 VSS.n440 VSS.n439 585
R1542 VSS.n439 VSS.n438 585
R1543 VSS.n441 VSS.n181 585
R1544 VSS.n418 VSS.n181 585
R1545 VSS.n445 VSS.n444 585
R1546 VSS.n446 VSS.n445 585
R1547 VSS.n443 VSS.n182 585
R1548 VSS.n415 VSS.n182 585
R1549 VSS.n442 VSS.n176 585
R1550 VSS.n452 VSS.n176 585
R1551 VSS.n126 VSS.n125 585
R1552 VSS.n126 VSS.n15 585
R1553 VSS.n469 VSS.n468 585
R1554 VSS.n468 VSS.n467 585
R1555 VSS.n470 VSS.n123 585
R1556 VSS.n123 VSS.n121 585
R1557 VSS.n473 VSS.n472 585
R1558 VSS.n474 VSS.n473 585
R1559 VSS.n471 VSS.n124 585
R1560 VSS.n124 VSS.n116 585
R1561 VSS.n92 VSS.n90 585
R1562 VSS.n484 VSS.n90 585
R1563 VSS.n637 VSS.n636 585
R1564 VSS.n638 VSS.n637 585
R1565 VSS.n386 VSS.n385 585
R1566 VSS.n384 VSS.n281 585
R1567 VSS.n383 VSS.n280 585
R1568 VSS.n388 VSS.n280 585
R1569 VSS.n382 VSS.n381 585
R1570 VSS.n380 VSS.n379 585
R1571 VSS.n378 VSS.n377 585
R1572 VSS.n376 VSS.n375 585
R1573 VSS.n374 VSS.n373 585
R1574 VSS.n372 VSS.n371 585
R1575 VSS.n370 VSS.n369 585
R1576 VSS.n368 VSS.n367 585
R1577 VSS.n366 VSS.n365 585
R1578 VSS.n364 VSS.n363 585
R1579 VSS.n362 VSS.n361 585
R1580 VSS.n360 VSS.n359 585
R1581 VSS.n358 VSS.n357 585
R1582 VSS.n356 VSS.n355 585
R1583 VSS.n354 VSS.n353 585
R1584 VSS.n352 VSS.n351 585
R1585 VSS.n350 VSS.n349 585
R1586 VSS.n348 VSS.n347 585
R1587 VSS.n346 VSS.n345 585
R1588 VSS.n344 VSS.n343 585
R1589 VSS.n342 VSS.n341 585
R1590 VSS.n340 VSS.n339 585
R1591 VSS.n338 VSS.n337 585
R1592 VSS.n336 VSS.n335 585
R1593 VSS.n333 VSS.n332 585
R1594 VSS.n331 VSS.n330 585
R1595 VSS.n329 VSS.n328 585
R1596 VSS.n327 VSS.n326 585
R1597 VSS.n325 VSS.n324 585
R1598 VSS.n323 VSS.n322 585
R1599 VSS.n321 VSS.n320 585
R1600 VSS.n319 VSS.n318 585
R1601 VSS.n317 VSS.n316 585
R1602 VSS.n315 VSS.n314 585
R1603 VSS.n313 VSS.n312 585
R1604 VSS.n311 VSS.n310 585
R1605 VSS.n309 VSS.n308 585
R1606 VSS.n307 VSS.n306 585
R1607 VSS.n305 VSS.n304 585
R1608 VSS.n303 VSS.n302 585
R1609 VSS.n301 VSS.n300 585
R1610 VSS.n299 VSS.n298 585
R1611 VSS.n297 VSS.n296 585
R1612 VSS.n295 VSS.n294 585
R1613 VSS.n293 VSS.n292 585
R1614 VSS.n291 VSS.n290 585
R1615 VSS.n289 VSS.n288 585
R1616 VSS.n287 VSS.n286 585
R1617 VSS.n224 VSS.n197 585
R1618 VSS.n388 VSS.n224 585
R1619 VSS.n390 VSS.n389 585
R1620 VSS.n389 VSS.n388 585
R1621 VSS.n199 VSS.n198 585
R1622 VSS.n238 VSS.n237 585
R1623 VSS.n240 VSS.n239 585
R1624 VSS.n242 VSS.n241 585
R1625 VSS.n244 VSS.n243 585
R1626 VSS.n246 VSS.n245 585
R1627 VSS.n248 VSS.n247 585
R1628 VSS.n250 VSS.n249 585
R1629 VSS.n252 VSS.n251 585
R1630 VSS.n254 VSS.n253 585
R1631 VSS.n256 VSS.n255 585
R1632 VSS.n258 VSS.n257 585
R1633 VSS.n260 VSS.n259 585
R1634 VSS.n262 VSS.n261 585
R1635 VSS.n264 VSS.n263 585
R1636 VSS.n266 VSS.n265 585
R1637 VSS.n268 VSS.n267 585
R1638 VSS.n270 VSS.n269 585
R1639 VSS.n272 VSS.n271 585
R1640 VSS.n274 VSS.n273 585
R1641 VSS.n276 VSS.n275 585
R1642 VSS.n277 VSS.n236 585
R1643 VSS.n279 VSS.n278 585
R1644 VSS.n388 VSS.n279 585
R1645 VSS.n191 VSS.n190 585
R1646 VSS.n192 VSS.n191 585
R1647 VSS.n641 VSS.n75 585
R1648 VSS.n641 VSS.n640 585
R1649 VSS.n479 VSS.n87 585
R1650 VSS.n639 VSS.n87 585
R1651 VSS.n480 VSS.n118 585
R1652 VSS.n118 VSS.n88 585
R1653 VSS.n482 VSS.n481 585
R1654 VSS.n483 VSS.n482 585
R1655 VSS.n478 VSS.n117 585
R1656 VSS.t1 VSS.n117 585
R1657 VSS.n477 VSS.n476 585
R1658 VSS.n476 VSS.n475 585
R1659 VSS.n120 VSS.n119 585
R1660 VSS.n466 VSS.n120 585
R1661 VSS.n459 VSS.n458 585
R1662 VSS.n460 VSS.n459 585
R1663 VSS.n456 VSS.n127 585
R1664 VSS.n127 VSS.n15 585
R1665 VSS.n455 VSS.n454 585
R1666 VSS.n454 VSS.n453 585
R1667 VSS.n174 VSS.n173 585
R1668 VSS.n414 VSS.n174 585
R1669 VSS.n433 VSS.n432 585
R1670 VSS.n432 VSS.n180 585
R1671 VSS.n434 VSS.n189 585
R1672 VSS.n419 VSS.n189 585
R1673 VSS.n436 VSS.n435 585
R1674 VSS.n437 VSS.n436 585
R1675 VSS.n431 VSS.n188 585
R1676 VSS.n193 VSS.n188 585
R1677 VSS.n430 VSS.n429 585
R1678 VSS.n429 VSS.n428 585
R1679 VSS.n660 VSS.n655 585
R1680 VSS.n857 VSS.n655 585
R1681 VSS.n67 VSS.n65 585
R1682 VSS.n68 VSS.n67 585
R1683 VSS.n865 VSS.n864 585
R1684 VSS.n864 VSS.n863 585
R1685 VSS.n66 VSS.n64 585
R1686 VSS.n648 VSS.n66 585
R1687 VSS.n647 VSS.n646 585
R1688 VSS.n649 VSS.n647 585
R1689 VSS.n645 VSS.n74 585
R1690 VSS.n74 VSS.n73 585
R1691 VSS.n661 VSS.n656 585
R1692 VSS.n856 VSS.n656 585
R1693 VSS.n664 VSS.n663 585
R1694 VSS.n666 VSS.n665 585
R1695 VSS.n668 VSS.n667 585
R1696 VSS.n669 VSS.n659 585
R1697 VSS.n671 VSS.n670 585
R1698 VSS.n712 VSS.n711 585
R1699 VSS.n714 VSS.n713 585
R1700 VSS.n716 VSS.n715 585
R1701 VSS.n718 VSS.n717 585
R1702 VSS.n720 VSS.n719 585
R1703 VSS.n722 VSS.n721 585
R1704 VSS.n724 VSS.n723 585
R1705 VSS.n726 VSS.n725 585
R1706 VSS.n728 VSS.n727 585
R1707 VSS.n730 VSS.n729 585
R1708 VSS.n732 VSS.n731 585
R1709 VSS.n734 VSS.n733 585
R1710 VSS.n736 VSS.n735 585
R1711 VSS.n738 VSS.n737 585
R1712 VSS.n740 VSS.n739 585
R1713 VSS.n742 VSS.n741 585
R1714 VSS.n744 VSS.n743 585
R1715 VSS.n746 VSS.n745 585
R1716 VSS.n748 VSS.n747 585
R1717 VSS.n750 VSS.n749 585
R1718 VSS.n752 VSS.n751 585
R1719 VSS.n754 VSS.n753 585
R1720 VSS.n756 VSS.n755 585
R1721 VSS.n758 VSS.n757 585
R1722 VSS.n760 VSS.n759 585
R1723 VSS.n762 VSS.n761 585
R1724 VSS.n764 VSS.n763 585
R1725 VSS.n766 VSS.n765 585
R1726 VSS.n768 VSS.n767 585
R1727 VSS.n770 VSS.n769 585
R1728 VSS.n772 VSS.n771 585
R1729 VSS.n774 VSS.n773 585
R1730 VSS.n776 VSS.n775 585
R1731 VSS.n778 VSS.n777 585
R1732 VSS.n780 VSS.n779 585
R1733 VSS.n782 VSS.n781 585
R1734 VSS.n784 VSS.n783 585
R1735 VSS.n786 VSS.n785 585
R1736 VSS.n788 VSS.n787 585
R1737 VSS.n790 VSS.n789 585
R1738 VSS.n792 VSS.n791 585
R1739 VSS.n794 VSS.n793 585
R1740 VSS.n796 VSS.n795 585
R1741 VSS.n798 VSS.n797 585
R1742 VSS.n800 VSS.n799 585
R1743 VSS.n802 VSS.n801 585
R1744 VSS.n804 VSS.n803 585
R1745 VSS.n806 VSS.n805 585
R1746 VSS.n808 VSS.n807 585
R1747 VSS.n810 VSS.n809 585
R1748 VSS.n812 VSS.n811 585
R1749 VSS.n814 VSS.n813 585
R1750 VSS.n816 VSS.n815 585
R1751 VSS.n818 VSS.n817 585
R1752 VSS.n820 VSS.n819 585
R1753 VSS.n822 VSS.n821 585
R1754 VSS.n824 VSS.n823 585
R1755 VSS.n826 VSS.n825 585
R1756 VSS.n828 VSS.n827 585
R1757 VSS.n830 VSS.n829 585
R1758 VSS.n832 VSS.n831 585
R1759 VSS.n834 VSS.n833 585
R1760 VSS.n836 VSS.n835 585
R1761 VSS.n838 VSS.n837 585
R1762 VSS.n840 VSS.n839 585
R1763 VSS.n842 VSS.n841 585
R1764 VSS.n844 VSS.n843 585
R1765 VSS.n846 VSS.n845 585
R1766 VSS.n848 VSS.n847 585
R1767 VSS.n850 VSS.n849 585
R1768 VSS.n851 VSS.n709 585
R1769 VSS.n853 VSS.n852 585
R1770 VSS.n710 VSS.n708 585
R1771 VSS.n856 VSS.n855 585
R1772 VSS.n72 VSS.n71 585
R1773 VSS.n73 VSS.n72 585
R1774 VSS.n651 VSS.n650 585
R1775 VSS.n650 VSS.n649 585
R1776 VSS.n652 VSS.n69 585
R1777 VSS.n648 VSS.n69 585
R1778 VSS.n862 VSS.n861 585
R1779 VSS.n863 VSS.n862 585
R1780 VSS.n860 VSS.n70 585
R1781 VSS.n70 VSS.n68 585
R1782 VSS.n859 VSS.n858 585
R1783 VSS.n858 VSS.n857 585
R1784 VSS.n643 VSS.n642 585
R1785 VSS.n85 VSS.n84 585
R1786 VSS.n83 VSS.n77 585
R1787 VSS.n82 VSS.n81 585
R1788 VSS.n79 VSS.n61 585
R1789 VSS.n869 VSS.n60 585
R1790 VSS.n871 VSS.n870 585
R1791 VSS.n873 VSS.n59 585
R1792 VSS.n874 VSS.n56 585
R1793 VSS.n877 VSS.n876 585
R1794 VSS.n57 VSS.n55 585
R1795 VSS.n519 VSS.n516 585
R1796 VSS.n521 VSS.n520 585
R1797 VSS.n522 VSS.n515 585
R1798 VSS.n524 VSS.n523 585
R1799 VSS.n526 VSS.n513 585
R1800 VSS.n528 VSS.n527 585
R1801 VSS.n529 VSS.n511 585
R1802 VSS.n531 VSS.n530 585
R1803 VSS.n533 VSS.n509 585
R1804 VSS.n535 VSS.n534 585
R1805 VSS.n536 VSS.n508 585
R1806 VSS.n538 VSS.n537 585
R1807 VSS.n540 VSS.n506 585
R1808 VSS.n542 VSS.n541 585
R1809 VSS.n543 VSS.n505 585
R1810 VSS.n545 VSS.n544 585
R1811 VSS.n547 VSS.n503 585
R1812 VSS.n549 VSS.n548 585
R1813 VSS.n550 VSS.n502 585
R1814 VSS.n552 VSS.n551 585
R1815 VSS.n554 VSS.n500 585
R1816 VSS.n556 VSS.n555 585
R1817 VSS.n557 VSS.n499 585
R1818 VSS.n559 VSS.n558 585
R1819 VSS.n561 VSS.n497 585
R1820 VSS.n563 VSS.n562 585
R1821 VSS.n564 VSS.n496 585
R1822 VSS.n566 VSS.n565 585
R1823 VSS.n568 VSS.n494 585
R1824 VSS.n570 VSS.n569 585
R1825 VSS.n571 VSS.n493 585
R1826 VSS.n573 VSS.n572 585
R1827 VSS.n575 VSS.n491 585
R1828 VSS.n577 VSS.n576 585
R1829 VSS.n578 VSS.n490 585
R1830 VSS.n580 VSS.n579 585
R1831 VSS.n582 VSS.n489 585
R1832 VSS.n583 VSS.n488 585
R1833 VSS.n586 VSS.n585 585
R1834 VSS.n589 VSS.n588 585
R1835 VSS.n591 VSS.n111 585
R1836 VSS.n593 VSS.n592 585
R1837 VSS.n594 VSS.n110 585
R1838 VSS.n596 VSS.n595 585
R1839 VSS.n598 VSS.n108 585
R1840 VSS.n600 VSS.n599 585
R1841 VSS.n601 VSS.n107 585
R1842 VSS.n603 VSS.n602 585
R1843 VSS.n605 VSS.n105 585
R1844 VSS.n607 VSS.n606 585
R1845 VSS.n608 VSS.n104 585
R1846 VSS.n610 VSS.n609 585
R1847 VSS.n612 VSS.n102 585
R1848 VSS.n614 VSS.n613 585
R1849 VSS.n615 VSS.n101 585
R1850 VSS.n617 VSS.n616 585
R1851 VSS.n619 VSS.n99 585
R1852 VSS.n621 VSS.n620 585
R1853 VSS.n622 VSS.n98 585
R1854 VSS.n624 VSS.n623 585
R1855 VSS.n626 VSS.n96 585
R1856 VSS.n628 VSS.n627 585
R1857 VSS.n629 VSS.n95 585
R1858 VSS.n631 VSS.n630 585
R1859 VSS.n631 VSS.n58 585
R1860 VSS.n634 VSS.n633 585
R1861 VSS.n635 VSS.n91 585
R1862 VSS.n20 VSS.n19 585
R1863 VSS.n19 VSS.n15 585
R1864 VSS.n961 VSS.n960 585
R1865 VSS.n959 VSS.n18 585
R1866 VSS.n958 VSS.n17 585
R1867 VSS.n963 VSS.n17 585
R1868 VSS.n957 VSS.n956 585
R1869 VSS.n955 VSS.n954 585
R1870 VSS.n953 VSS.n952 585
R1871 VSS.n950 VSS.n949 585
R1872 VSS.n948 VSS.n947 585
R1873 VSS.n946 VSS.n945 585
R1874 VSS.n5 VSS.n2 585
R1875 VSS.n966 VSS.n965 585
R1876 VSS.n4 VSS.n3 585
R1877 VSS.n29 VSS.n28 585
R1878 VSS.n31 VSS.n30 585
R1879 VSS.n936 VSS.n935 585
R1880 VSS.n934 VSS.n933 585
R1881 VSS.n932 VSS.n931 585
R1882 VSS.n930 VSS.n929 585
R1883 VSS.n400 VSS.n32 585
R1884 VSS.n402 VSS.n401 585
R1885 VSS.n404 VSS.n403 585
R1886 VSS.n406 VSS.n405 585
R1887 VSS.n408 VSS.n407 585
R1888 VSS.n410 VSS.n409 585
R1889 VSS.n386 VSS.n184 480.488
R1890 VSS.n637 VSS.n91 480.488
R1891 VSS.n963 VSS.n16 256.663
R1892 VSS.n388 VSS.n212 256.663
R1893 VSS.n388 VSS.n213 256.663
R1894 VSS.n388 VSS.n214 256.663
R1895 VSS.n388 VSS.n215 256.663
R1896 VSS.n388 VSS.n216 256.663
R1897 VSS.n388 VSS.n217 256.663
R1898 VSS.n388 VSS.n218 256.663
R1899 VSS.n388 VSS.n219 256.663
R1900 VSS.n388 VSS.n220 256.663
R1901 VSS.n388 VSS.n221 256.663
R1902 VSS.n388 VSS.n222 256.663
R1903 VSS.n388 VSS.n223 256.663
R1904 VSS.n388 VSS.n225 256.663
R1905 VSS.n388 VSS.n226 256.663
R1906 VSS.n388 VSS.n227 256.663
R1907 VSS.n388 VSS.n228 256.663
R1908 VSS.n388 VSS.n229 256.663
R1909 VSS.n388 VSS.n230 256.663
R1910 VSS.n388 VSS.n231 256.663
R1911 VSS.n388 VSS.n232 256.663
R1912 VSS.n388 VSS.n233 256.663
R1913 VSS.n388 VSS.n234 256.663
R1914 VSS.n388 VSS.n235 256.663
R1915 VSS.n856 VSS.n657 256.663
R1916 VSS.n856 VSS.n658 256.663
R1917 VSS.n856 VSS.n672 256.663
R1918 VSS.n856 VSS.n673 256.663
R1919 VSS.n856 VSS.n674 256.663
R1920 VSS.n856 VSS.n675 256.663
R1921 VSS.n856 VSS.n676 256.663
R1922 VSS.n856 VSS.n677 256.663
R1923 VSS.n856 VSS.n678 256.663
R1924 VSS.n856 VSS.n679 256.663
R1925 VSS.n856 VSS.n680 256.663
R1926 VSS.n856 VSS.n681 256.663
R1927 VSS.n856 VSS.n682 256.663
R1928 VSS.n856 VSS.n683 256.663
R1929 VSS.n856 VSS.n684 256.663
R1930 VSS.n856 VSS.n685 256.663
R1931 VSS.n856 VSS.n686 256.663
R1932 VSS.n856 VSS.n687 256.663
R1933 VSS.n856 VSS.n688 256.663
R1934 VSS.n856 VSS.n689 256.663
R1935 VSS.n856 VSS.n690 256.663
R1936 VSS.n856 VSS.n691 256.663
R1937 VSS.n856 VSS.n692 256.663
R1938 VSS.n856 VSS.n693 256.663
R1939 VSS.n856 VSS.n694 256.663
R1940 VSS.n856 VSS.n695 256.663
R1941 VSS.n856 VSS.n696 256.663
R1942 VSS.n856 VSS.n697 256.663
R1943 VSS.n856 VSS.n698 256.663
R1944 VSS.n856 VSS.n699 256.663
R1945 VSS.n856 VSS.n700 256.663
R1946 VSS.n856 VSS.n701 256.663
R1947 VSS.n856 VSS.n702 256.663
R1948 VSS.n856 VSS.n703 256.663
R1949 VSS.n856 VSS.n704 256.663
R1950 VSS.n856 VSS.n705 256.663
R1951 VSS.n856 VSS.n706 256.663
R1952 VSS.n856 VSS.n707 256.663
R1953 VSS.n856 VSS.n854 256.663
R1954 VSS.n86 VSS.n58 256.663
R1955 VSS.n80 VSS.n58 256.663
R1956 VSS.n78 VSS.n58 256.663
R1957 VSS.n872 VSS.n58 256.663
R1958 VSS.n875 VSS.n58 256.663
R1959 VSS.n518 VSS.n58 256.663
R1960 VSS.n517 VSS.n58 256.663
R1961 VSS.n525 VSS.n58 256.663
R1962 VSS.n514 VSS.n58 256.663
R1963 VSS.n532 VSS.n58 256.663
R1964 VSS.n510 VSS.n58 256.663
R1965 VSS.n539 VSS.n58 256.663
R1966 VSS.n507 VSS.n58 256.663
R1967 VSS.n546 VSS.n58 256.663
R1968 VSS.n504 VSS.n58 256.663
R1969 VSS.n553 VSS.n58 256.663
R1970 VSS.n501 VSS.n58 256.663
R1971 VSS.n560 VSS.n58 256.663
R1972 VSS.n498 VSS.n58 256.663
R1973 VSS.n567 VSS.n58 256.663
R1974 VSS.n495 VSS.n58 256.663
R1975 VSS.n574 VSS.n58 256.663
R1976 VSS.n492 VSS.n58 256.663
R1977 VSS.n581 VSS.n58 256.663
R1978 VSS.n584 VSS.n58 256.663
R1979 VSS.n963 VSS.n962 256.663
R1980 VSS.n963 VSS.n6 256.663
R1981 VSS.n963 VSS.n7 256.663
R1982 VSS.n963 VSS.n8 256.663
R1983 VSS.n964 VSS.n963 256.663
R1984 VSS.n963 VSS.n9 256.663
R1985 VSS.n963 VSS.n10 256.663
R1986 VSS.n963 VSS.n11 256.663
R1987 VSS.n963 VSS.n12 256.663
R1988 VSS.n963 VSS.n13 256.663
R1989 VSS.n963 VSS.n14 256.663
R1990 VSS.n388 VSS.n387 254.827
R1991 VSS.n388 VSS.n200 254.827
R1992 VSS.n388 VSS.n201 254.827
R1993 VSS.n388 VSS.n202 254.827
R1994 VSS.n388 VSS.n203 254.827
R1995 VSS.n388 VSS.n204 254.827
R1996 VSS.n388 VSS.n205 254.827
R1997 VSS.n388 VSS.n206 254.827
R1998 VSS.n388 VSS.n207 254.827
R1999 VSS.n388 VSS.n208 254.827
R2000 VSS.n388 VSS.n209 254.827
R2001 VSS.n388 VSS.n210 254.827
R2002 VSS.n388 VSS.n211 254.827
R2003 VSS.n590 VSS.n58 254.827
R2004 VSS.n112 VSS.n58 254.827
R2005 VSS.n597 VSS.n58 254.827
R2006 VSS.n109 VSS.n58 254.827
R2007 VSS.n604 VSS.n58 254.827
R2008 VSS.n106 VSS.n58 254.827
R2009 VSS.n611 VSS.n58 254.827
R2010 VSS.n103 VSS.n58 254.827
R2011 VSS.n618 VSS.n58 254.827
R2012 VSS.n100 VSS.n58 254.827
R2013 VSS.n625 VSS.n58 254.827
R2014 VSS.n97 VSS.n58 254.827
R2015 VSS.n94 VSS.n58 254.827
R2016 VSS.n335 VSS.n334 249.855
R2017 VSS.n589 VSS.n113 249.855
R2018 VSS.n279 VSS.n191 245.049
R2019 VSS.n961 VSS.n19 235.44
R2020 VSS.n334 VSS.n285 230.635
R2021 VSS.n113 VSS.n89 230.635
R2022 VSS.n334 VSS.n333 216.22
R2023 VSS.n389 VSS.n195 211.416
R2024 VSS.n642 VSS.n641 204.208
R2025 VSS.n585 VSS.n113 201.805
R2026 VSS.n399 VSS.n393 189.793
R2027 VSS.n171 VSS.n160 185
R2028 VSS.n892 VSS.n891 185
R2029 VSS.n917 VSS.n916 185
R2030 VSS.n285 VSS.n186 172.976
R2031 VSS.n186 VSS.n179 172.976
R2032 VSS.n447 VSS.n179 172.976
R2033 VSS.n447 VSS.n177 172.976
R2034 VSS.n451 VSS.n177 172.976
R2035 VSS.n281 VSS.n280 172.976
R2036 VSS.n381 VSS.n280 172.976
R2037 VSS.n379 VSS.n378 172.976
R2038 VSS.n375 VSS.n374 172.976
R2039 VSS.n371 VSS.n370 172.976
R2040 VSS.n367 VSS.n366 172.976
R2041 VSS.n363 VSS.n362 172.976
R2042 VSS.n359 VSS.n358 172.976
R2043 VSS.n355 VSS.n354 172.976
R2044 VSS.n351 VSS.n350 172.976
R2045 VSS.n347 VSS.n346 172.976
R2046 VSS.n343 VSS.n342 172.976
R2047 VSS.n339 VSS.n338 172.976
R2048 VSS.n465 VSS.n461 172.976
R2049 VSS.n461 VSS.n122 172.976
R2050 VSS.n122 VSS.n115 172.976
R2051 VSS.n485 VSS.n115 172.976
R2052 VSS.n485 VSS.n89 172.976
R2053 VSS.n631 VSS.n95 172.976
R2054 VSS.n627 VSS.n626 172.976
R2055 VSS.n624 VSS.n98 172.976
R2056 VSS.n620 VSS.n619 172.976
R2057 VSS.n617 VSS.n101 172.976
R2058 VSS.n613 VSS.n612 172.976
R2059 VSS.n610 VSS.n104 172.976
R2060 VSS.n606 VSS.n605 172.976
R2061 VSS.n603 VSS.n107 172.976
R2062 VSS.n599 VSS.n598 172.976
R2063 VSS.n596 VSS.n110 172.976
R2064 VSS.n592 VSS.n591 172.976
R2065 VSS.n439 VSS.n184 172.976
R2066 VSS.n439 VSS.n181 172.976
R2067 VSS.n445 VSS.n181 172.976
R2068 VSS.n445 VSS.n182 172.976
R2069 VSS.n182 VSS.n176 172.976
R2070 VSS.n176 VSS.n126 172.976
R2071 VSS.n468 VSS.n126 172.976
R2072 VSS.n468 VSS.n123 172.976
R2073 VSS.n473 VSS.n123 172.976
R2074 VSS.n473 VSS.n124 172.976
R2075 VSS.n124 VSS.n90 172.976
R2076 VSS.n637 VSS.n90 172.976
R2077 VSS.n429 VSS.n188 163.367
R2078 VSS.n436 VSS.n188 163.367
R2079 VSS.n436 VSS.n189 163.367
R2080 VSS.n432 VSS.n189 163.367
R2081 VSS.n432 VSS.n174 163.367
R2082 VSS.n454 VSS.n174 163.367
R2083 VSS.n454 VSS.n127 163.367
R2084 VSS.n459 VSS.n127 163.367
R2085 VSS.n459 VSS.n120 163.367
R2086 VSS.n476 VSS.n120 163.367
R2087 VSS.n476 VSS.n117 163.367
R2088 VSS.n482 VSS.n117 163.367
R2089 VSS.n482 VSS.n118 163.367
R2090 VSS.n118 VSS.n87 163.367
R2091 VSS.n330 VSS.n329 163.367
R2092 VSS.n326 VSS.n325 163.367
R2093 VSS.n322 VSS.n321 163.367
R2094 VSS.n318 VSS.n317 163.367
R2095 VSS.n314 VSS.n313 163.367
R2096 VSS.n310 VSS.n309 163.367
R2097 VSS.n306 VSS.n305 163.367
R2098 VSS.n302 VSS.n301 163.367
R2099 VSS.n298 VSS.n297 163.367
R2100 VSS.n294 VSS.n293 163.367
R2101 VSS.n290 VSS.n289 163.367
R2102 VSS.n286 VSS.n224 163.367
R2103 VSS.n389 VSS.n199 163.367
R2104 VSS.n239 VSS.n238 163.367
R2105 VSS.n243 VSS.n242 163.367
R2106 VSS.n247 VSS.n246 163.367
R2107 VSS.n251 VSS.n250 163.367
R2108 VSS.n255 VSS.n254 163.367
R2109 VSS.n259 VSS.n258 163.367
R2110 VSS.n263 VSS.n262 163.367
R2111 VSS.n267 VSS.n266 163.367
R2112 VSS.n271 VSS.n270 163.367
R2113 VSS.n275 VSS.n274 163.367
R2114 VSS.n279 VSS.n236 163.367
R2115 VSS.n426 VSS.n196 163.367
R2116 VSS.n422 VSS.n196 163.367
R2117 VSS.n422 VSS.n421 163.367
R2118 VSS.n421 VSS.n417 163.367
R2119 VSS.n417 VSS.n393 163.367
R2120 VSS.n18 VSS.n17 163.367
R2121 VSS.n956 VSS.n17 163.367
R2122 VSS.n954 VSS.n953 163.367
R2123 VSS.n949 VSS.n948 163.367
R2124 VSS.n945 VSS.n5 163.367
R2125 VSS.n965 VSS.n4 163.367
R2126 VSS.n30 VSS.n29 163.367
R2127 VSS.n935 VSS.n934 163.367
R2128 VSS.n931 VSS.n930 163.367
R2129 VSS.n401 VSS.n400 163.367
R2130 VSS.n405 VSS.n404 163.367
R2131 VSS.n409 VSS.n408 163.367
R2132 VSS.n647 VSS.n74 163.367
R2133 VSS.n647 VSS.n66 163.367
R2134 VSS.n864 VSS.n66 163.367
R2135 VSS.n864 VSS.n67 163.367
R2136 VSS.n655 VSS.n67 163.367
R2137 VSS.n853 VSS.n709 163.367
R2138 VSS.n849 VSS.n848 163.367
R2139 VSS.n845 VSS.n844 163.367
R2140 VSS.n841 VSS.n840 163.367
R2141 VSS.n837 VSS.n836 163.367
R2142 VSS.n833 VSS.n832 163.367
R2143 VSS.n829 VSS.n828 163.367
R2144 VSS.n825 VSS.n824 163.367
R2145 VSS.n821 VSS.n820 163.367
R2146 VSS.n817 VSS.n816 163.367
R2147 VSS.n813 VSS.n812 163.367
R2148 VSS.n809 VSS.n808 163.367
R2149 VSS.n805 VSS.n804 163.367
R2150 VSS.n801 VSS.n800 163.367
R2151 VSS.n797 VSS.n796 163.367
R2152 VSS.n793 VSS.n792 163.367
R2153 VSS.n789 VSS.n788 163.367
R2154 VSS.n785 VSS.n784 163.367
R2155 VSS.n781 VSS.n780 163.367
R2156 VSS.n777 VSS.n776 163.367
R2157 VSS.n773 VSS.n772 163.367
R2158 VSS.n769 VSS.n768 163.367
R2159 VSS.n765 VSS.n764 163.367
R2160 VSS.n761 VSS.n760 163.367
R2161 VSS.n757 VSS.n756 163.367
R2162 VSS.n753 VSS.n752 163.367
R2163 VSS.n749 VSS.n748 163.367
R2164 VSS.n745 VSS.n744 163.367
R2165 VSS.n741 VSS.n740 163.367
R2166 VSS.n737 VSS.n736 163.367
R2167 VSS.n733 VSS.n732 163.367
R2168 VSS.n729 VSS.n728 163.367
R2169 VSS.n725 VSS.n724 163.367
R2170 VSS.n721 VSS.n720 163.367
R2171 VSS.n717 VSS.n716 163.367
R2172 VSS.n713 VSS.n712 163.367
R2173 VSS.n671 VSS.n659 163.367
R2174 VSS.n667 VSS.n666 163.367
R2175 VSS.n650 VSS.n72 163.367
R2176 VSS.n650 VSS.n69 163.367
R2177 VSS.n862 VSS.n69 163.367
R2178 VSS.n862 VSS.n70 163.367
R2179 VSS.n858 VSS.n70 163.367
R2180 VSS.n583 VSS.n582 163.367
R2181 VSS.n580 VSS.n490 163.367
R2182 VSS.n576 VSS.n575 163.367
R2183 VSS.n573 VSS.n493 163.367
R2184 VSS.n569 VSS.n568 163.367
R2185 VSS.n566 VSS.n496 163.367
R2186 VSS.n562 VSS.n561 163.367
R2187 VSS.n559 VSS.n499 163.367
R2188 VSS.n555 VSS.n554 163.367
R2189 VSS.n552 VSS.n502 163.367
R2190 VSS.n548 VSS.n547 163.367
R2191 VSS.n545 VSS.n505 163.367
R2192 VSS.n541 VSS.n540 163.367
R2193 VSS.n538 VSS.n508 163.367
R2194 VSS.n534 VSS.n533 163.367
R2195 VSS.n531 VSS.n511 163.367
R2196 VSS.n527 VSS.n526 163.367
R2197 VSS.n524 VSS.n515 163.367
R2198 VSS.n520 VSS.n519 163.367
R2199 VSS.n876 VSS.n57 163.367
R2200 VSS.n874 VSS.n873 163.367
R2201 VSS.n871 VSS.n60 163.367
R2202 VSS.n81 VSS.n79 163.367
R2203 VSS.n85 VSS.n77 163.367
R2204 VSS.n426 VSS.n195 148.952
R2205 VSS.n708 VSS.n654 148.952
R2206 VSS.n663 VSS.n662 148.952
R2207 VSS.n465 VSS.n19 129.732
R2208 VSS.n397 VSS.t16 128.501
R2209 VSS.n969 VSS.t2 125.684
R2210 VSS.n429 VSS.n191 124.927
R2211 VSS.n641 VSS.n87 124.927
R2212 VSS.n33 VSS.t3 124.912
R2213 VSS.n641 VSS.n74 112.915
R2214 VSS.n662 VSS.n655 112.915
R2215 VSS.n632 VSS.n72 112.915
R2216 VSS.n858 VSS.n654 112.915
R2217 VSS.n633 VSS.n632 108.111
R2218 VSS.n27 VSS.n26 89.708
R2219 VSS.n22 VSS.n21 89.708
R2220 VSS.n918 VSS.n917 88.1117
R2221 VSS.n892 VSS.n50 88.0025
R2222 VSS.n160 VSS.n129 86.8457
R2223 VSS.n160 VSS.n159 86.6339
R2224 VSS.n162 VSS.n160 86.1871
R2225 VSS.n166 VSS.n160 86.1871
R2226 VSS.n160 VSS.n131 86.1871
R2227 VSS.n892 VSS.n48 86.1871
R2228 VSS.n893 VSS.n892 86.1871
R2229 VSS.n892 VSS.n889 86.1871
R2230 VSS.n892 VSS.n51 86.1871
R2231 VSS.n917 VSS.n41 86.1871
R2232 VSS.n917 VSS.n40 86.1871
R2233 VSS.n917 VSS.n39 86.1871
R2234 VSS.n917 VSS.n38 86.1871
R2235 VSS.n387 VSS.n386 75.3491
R2236 VSS.n381 VSS.n200 75.3491
R2237 VSS.n378 VSS.n201 75.3491
R2238 VSS.n374 VSS.n202 75.3491
R2239 VSS.n370 VSS.n203 75.3491
R2240 VSS.n366 VSS.n204 75.3491
R2241 VSS.n362 VSS.n205 75.3491
R2242 VSS.n358 VSS.n206 75.3491
R2243 VSS.n354 VSS.n207 75.3491
R2244 VSS.n350 VSS.n208 75.3491
R2245 VSS.n346 VSS.n209 75.3491
R2246 VSS.n342 VSS.n210 75.3491
R2247 VSS.n338 VSS.n211 75.3491
R2248 VSS.n633 VSS.n94 75.3491
R2249 VSS.n627 VSS.n97 75.3491
R2250 VSS.n625 VSS.n624 75.3491
R2251 VSS.n620 VSS.n100 75.3491
R2252 VSS.n618 VSS.n617 75.3491
R2253 VSS.n613 VSS.n103 75.3491
R2254 VSS.n611 VSS.n610 75.3491
R2255 VSS.n606 VSS.n106 75.3491
R2256 VSS.n604 VSS.n603 75.3491
R2257 VSS.n599 VSS.n109 75.3491
R2258 VSS.n597 VSS.n596 75.3491
R2259 VSS.n592 VSS.n112 75.3491
R2260 VSS.n590 VSS.n589 75.3491
R2261 VSS.n387 VSS.n281 75.3491
R2262 VSS.n379 VSS.n200 75.3491
R2263 VSS.n375 VSS.n201 75.3491
R2264 VSS.n371 VSS.n202 75.3491
R2265 VSS.n367 VSS.n203 75.3491
R2266 VSS.n363 VSS.n204 75.3491
R2267 VSS.n359 VSS.n205 75.3491
R2268 VSS.n355 VSS.n206 75.3491
R2269 VSS.n351 VSS.n207 75.3491
R2270 VSS.n347 VSS.n208 75.3491
R2271 VSS.n343 VSS.n209 75.3491
R2272 VSS.n339 VSS.n210 75.3491
R2273 VSS.n335 VSS.n211 75.3491
R2274 VSS.n591 VSS.n590 75.3491
R2275 VSS.n112 VSS.n110 75.3491
R2276 VSS.n598 VSS.n597 75.3491
R2277 VSS.n109 VSS.n107 75.3491
R2278 VSS.n605 VSS.n604 75.3491
R2279 VSS.n106 VSS.n104 75.3491
R2280 VSS.n612 VSS.n611 75.3491
R2281 VSS.n103 VSS.n101 75.3491
R2282 VSS.n619 VSS.n618 75.3491
R2283 VSS.n100 VSS.n98 75.3491
R2284 VSS.n626 VSS.n625 75.3491
R2285 VSS.n97 VSS.n95 75.3491
R2286 VSS.n94 VSS.n91 75.3491
R2287 VSS.n333 VSS.n212 71.676
R2288 VSS.n329 VSS.n213 71.676
R2289 VSS.n325 VSS.n214 71.676
R2290 VSS.n321 VSS.n215 71.676
R2291 VSS.n317 VSS.n216 71.676
R2292 VSS.n313 VSS.n217 71.676
R2293 VSS.n309 VSS.n218 71.676
R2294 VSS.n305 VSS.n219 71.676
R2295 VSS.n301 VSS.n220 71.676
R2296 VSS.n297 VSS.n221 71.676
R2297 VSS.n293 VSS.n222 71.676
R2298 VSS.n289 VSS.n223 71.676
R2299 VSS.n225 VSS.n199 71.676
R2300 VSS.n239 VSS.n226 71.676
R2301 VSS.n243 VSS.n227 71.676
R2302 VSS.n247 VSS.n228 71.676
R2303 VSS.n251 VSS.n229 71.676
R2304 VSS.n255 VSS.n230 71.676
R2305 VSS.n259 VSS.n231 71.676
R2306 VSS.n263 VSS.n232 71.676
R2307 VSS.n267 VSS.n233 71.676
R2308 VSS.n271 VSS.n234 71.676
R2309 VSS.n275 VSS.n235 71.676
R2310 VSS.n962 VSS.n961 71.676
R2311 VSS.n956 VSS.n6 71.676
R2312 VSS.n953 VSS.n7 71.676
R2313 VSS.n948 VSS.n8 71.676
R2314 VSS.n964 VSS.n5 71.676
R2315 VSS.n9 VSS.n4 71.676
R2316 VSS.n30 VSS.n10 71.676
R2317 VSS.n934 VSS.n11 71.676
R2318 VSS.n930 VSS.n12 71.676
R2319 VSS.n401 VSS.n13 71.676
R2320 VSS.n405 VSS.n14 71.676
R2321 VSS.n399 VSS.n16 71.676
R2322 VSS.n854 VSS.n853 71.676
R2323 VSS.n849 VSS.n707 71.676
R2324 VSS.n845 VSS.n706 71.676
R2325 VSS.n841 VSS.n705 71.676
R2326 VSS.n837 VSS.n704 71.676
R2327 VSS.n833 VSS.n703 71.676
R2328 VSS.n829 VSS.n702 71.676
R2329 VSS.n825 VSS.n701 71.676
R2330 VSS.n821 VSS.n700 71.676
R2331 VSS.n817 VSS.n699 71.676
R2332 VSS.n813 VSS.n698 71.676
R2333 VSS.n809 VSS.n697 71.676
R2334 VSS.n805 VSS.n696 71.676
R2335 VSS.n801 VSS.n695 71.676
R2336 VSS.n797 VSS.n694 71.676
R2337 VSS.n793 VSS.n693 71.676
R2338 VSS.n789 VSS.n692 71.676
R2339 VSS.n785 VSS.n691 71.676
R2340 VSS.n781 VSS.n690 71.676
R2341 VSS.n777 VSS.n689 71.676
R2342 VSS.n773 VSS.n688 71.676
R2343 VSS.n769 VSS.n687 71.676
R2344 VSS.n765 VSS.n686 71.676
R2345 VSS.n761 VSS.n685 71.676
R2346 VSS.n757 VSS.n684 71.676
R2347 VSS.n753 VSS.n683 71.676
R2348 VSS.n749 VSS.n682 71.676
R2349 VSS.n745 VSS.n681 71.676
R2350 VSS.n741 VSS.n680 71.676
R2351 VSS.n737 VSS.n679 71.676
R2352 VSS.n733 VSS.n678 71.676
R2353 VSS.n729 VSS.n677 71.676
R2354 VSS.n725 VSS.n676 71.676
R2355 VSS.n721 VSS.n675 71.676
R2356 VSS.n717 VSS.n674 71.676
R2357 VSS.n713 VSS.n673 71.676
R2358 VSS.n672 VSS.n671 71.676
R2359 VSS.n667 VSS.n658 71.676
R2360 VSS.n663 VSS.n657 71.676
R2361 VSS.n584 VSS.n583 71.676
R2362 VSS.n581 VSS.n580 71.676
R2363 VSS.n576 VSS.n492 71.676
R2364 VSS.n574 VSS.n573 71.676
R2365 VSS.n569 VSS.n495 71.676
R2366 VSS.n567 VSS.n566 71.676
R2367 VSS.n562 VSS.n498 71.676
R2368 VSS.n560 VSS.n559 71.676
R2369 VSS.n555 VSS.n501 71.676
R2370 VSS.n553 VSS.n552 71.676
R2371 VSS.n548 VSS.n504 71.676
R2372 VSS.n546 VSS.n545 71.676
R2373 VSS.n541 VSS.n507 71.676
R2374 VSS.n539 VSS.n538 71.676
R2375 VSS.n534 VSS.n510 71.676
R2376 VSS.n532 VSS.n531 71.676
R2377 VSS.n527 VSS.n514 71.676
R2378 VSS.n525 VSS.n524 71.676
R2379 VSS.n520 VSS.n517 71.676
R2380 VSS.n518 VSS.n57 71.676
R2381 VSS.n875 VSS.n874 71.676
R2382 VSS.n872 VSS.n871 71.676
R2383 VSS.n79 VSS.n78 71.676
R2384 VSS.n80 VSS.n77 71.676
R2385 VSS.n642 VSS.n86 71.676
R2386 VSS.n330 VSS.n212 71.676
R2387 VSS.n326 VSS.n213 71.676
R2388 VSS.n322 VSS.n214 71.676
R2389 VSS.n318 VSS.n215 71.676
R2390 VSS.n314 VSS.n216 71.676
R2391 VSS.n310 VSS.n217 71.676
R2392 VSS.n306 VSS.n218 71.676
R2393 VSS.n302 VSS.n219 71.676
R2394 VSS.n298 VSS.n220 71.676
R2395 VSS.n294 VSS.n221 71.676
R2396 VSS.n290 VSS.n222 71.676
R2397 VSS.n286 VSS.n223 71.676
R2398 VSS.n238 VSS.n225 71.676
R2399 VSS.n242 VSS.n226 71.676
R2400 VSS.n246 VSS.n227 71.676
R2401 VSS.n250 VSS.n228 71.676
R2402 VSS.n254 VSS.n229 71.676
R2403 VSS.n258 VSS.n230 71.676
R2404 VSS.n262 VSS.n231 71.676
R2405 VSS.n266 VSS.n232 71.676
R2406 VSS.n270 VSS.n233 71.676
R2407 VSS.n274 VSS.n234 71.676
R2408 VSS.n236 VSS.n235 71.676
R2409 VSS.n666 VSS.n657 71.676
R2410 VSS.n659 VSS.n658 71.676
R2411 VSS.n712 VSS.n672 71.676
R2412 VSS.n716 VSS.n673 71.676
R2413 VSS.n720 VSS.n674 71.676
R2414 VSS.n724 VSS.n675 71.676
R2415 VSS.n728 VSS.n676 71.676
R2416 VSS.n732 VSS.n677 71.676
R2417 VSS.n736 VSS.n678 71.676
R2418 VSS.n740 VSS.n679 71.676
R2419 VSS.n744 VSS.n680 71.676
R2420 VSS.n748 VSS.n681 71.676
R2421 VSS.n752 VSS.n682 71.676
R2422 VSS.n756 VSS.n683 71.676
R2423 VSS.n760 VSS.n684 71.676
R2424 VSS.n764 VSS.n685 71.676
R2425 VSS.n768 VSS.n686 71.676
R2426 VSS.n772 VSS.n687 71.676
R2427 VSS.n776 VSS.n688 71.676
R2428 VSS.n780 VSS.n689 71.676
R2429 VSS.n784 VSS.n690 71.676
R2430 VSS.n788 VSS.n691 71.676
R2431 VSS.n792 VSS.n692 71.676
R2432 VSS.n796 VSS.n693 71.676
R2433 VSS.n800 VSS.n694 71.676
R2434 VSS.n804 VSS.n695 71.676
R2435 VSS.n808 VSS.n696 71.676
R2436 VSS.n812 VSS.n697 71.676
R2437 VSS.n816 VSS.n698 71.676
R2438 VSS.n820 VSS.n699 71.676
R2439 VSS.n824 VSS.n700 71.676
R2440 VSS.n828 VSS.n701 71.676
R2441 VSS.n832 VSS.n702 71.676
R2442 VSS.n836 VSS.n703 71.676
R2443 VSS.n840 VSS.n704 71.676
R2444 VSS.n844 VSS.n705 71.676
R2445 VSS.n848 VSS.n706 71.676
R2446 VSS.n709 VSS.n707 71.676
R2447 VSS.n854 VSS.n708 71.676
R2448 VSS.n86 VSS.n85 71.676
R2449 VSS.n81 VSS.n80 71.676
R2450 VSS.n78 VSS.n60 71.676
R2451 VSS.n873 VSS.n872 71.676
R2452 VSS.n876 VSS.n875 71.676
R2453 VSS.n519 VSS.n518 71.676
R2454 VSS.n517 VSS.n515 71.676
R2455 VSS.n526 VSS.n525 71.676
R2456 VSS.n514 VSS.n511 71.676
R2457 VSS.n533 VSS.n532 71.676
R2458 VSS.n510 VSS.n508 71.676
R2459 VSS.n540 VSS.n539 71.676
R2460 VSS.n507 VSS.n505 71.676
R2461 VSS.n547 VSS.n546 71.676
R2462 VSS.n504 VSS.n502 71.676
R2463 VSS.n554 VSS.n553 71.676
R2464 VSS.n501 VSS.n499 71.676
R2465 VSS.n561 VSS.n560 71.676
R2466 VSS.n498 VSS.n496 71.676
R2467 VSS.n568 VSS.n567 71.676
R2468 VSS.n495 VSS.n493 71.676
R2469 VSS.n575 VSS.n574 71.676
R2470 VSS.n492 VSS.n490 71.676
R2471 VSS.n582 VSS.n581 71.676
R2472 VSS.n585 VSS.n584 71.676
R2473 VSS.n962 VSS.n18 71.676
R2474 VSS.n954 VSS.n6 71.676
R2475 VSS.n949 VSS.n7 71.676
R2476 VSS.n945 VSS.n8 71.676
R2477 VSS.n965 VSS.n964 71.676
R2478 VSS.n29 VSS.n9 71.676
R2479 VSS.n935 VSS.n10 71.676
R2480 VSS.n931 VSS.n11 71.676
R2481 VSS.n400 VSS.n12 71.676
R2482 VSS.n404 VSS.n13 71.676
R2483 VSS.n408 VSS.n14 71.676
R2484 VSS.n409 VSS.n16 71.676
R2485 VSS.n632 VSS.n631 64.8664
R2486 VSS.n224 VSS.n195 60.0615
R2487 VSS.n73 VSS.n58 56.5591
R2488 VSS.n857 VSS.n856 56.5591
R2489 VSS.n428 VSS.n192 43.7049
R2490 VSS.n640 VSS.n639 43.7049
R2491 VSS.n649 VSS.n73 43.7049
R2492 VSS.n649 VSS.n648 43.7049
R2493 VSS.n863 VSS.n68 43.7049
R2494 VSS.n857 VSS.n68 43.7049
R2495 VSS.n867 VSS.n866 42.9222
R2496 VSS.n467 VSS.n466 41.134
R2497 VSS.n475 VSS.n121 38.5632
R2498 VSS.n474 VSS.t1 35.9923
R2499 VSS.n968 VSS.n967 34.8805
R2500 VSS.n928 VSS.n927 34.8805
R2501 VSS.n452 VSS.n175 34.7069
R2502 VSS.n483 VSS.n116 33.4215
R2503 VSS.n416 VSS.n415 32.1361
R2504 VSS.n158 VSS.n76 31.7445
R2505 VSS.n879 VSS.n878 31.7445
R2506 VSS.n512 VSS.n36 31.7445
R2507 VSS.n385 VSS.n183 31.22
R2508 VSS.n636 VSS.n635 31.22
R2509 VSS.n484 VSS.n88 30.8506
R2510 VSS.n26 VSS.t7 30.0005
R2511 VSS.n26 VSS.t15 30.0005
R2512 VSS.n21 VSS.t17 30.0005
R2513 VSS.n21 VSS.t13 30.0005
R2514 VSS.t8 VSS.n15 28.2798
R2515 VSS.n639 VSS.n638 28.2798
R2516 VSS.n167 VSS.n165 27.1064
R2517 VSS.n171 VSS.n130 27.1064
R2518 VSS.n135 VSS.n134 27.1064
R2519 VSS.n137 VSS.n132 27.1064
R2520 VSS.n891 VSS.n890 27.1064
R2521 VSS.n895 VSS.n894 27.1064
R2522 VSS.n888 VSS.n49 27.1064
R2523 VSS.n884 VSS.n52 27.1064
R2524 VSS.n882 VSS.n881 27.1064
R2525 VSS.n916 VSS.n42 27.1064
R2526 VSS.n911 VSS.n910 27.1064
R2527 VSS.n907 VSS.n906 27.1064
R2528 VSS.n903 VSS.n902 27.1064
R2529 VSS.n418 VSS.n187 26.9944
R2530 VSS.n457 VSS.n172 25.0885
R2531 VSS.n938 VSS.n937 24.6405
R2532 VSS.n951 VSS.n944 24.6405
R2533 VSS.n438 VSS.n185 24.4235
R2534 VSS.n446 VSS.t6 24.4235
R2535 VSS.n868 VSS.n867 23.8405
R2536 VSS.n867 VSS.n62 23.5205
R2537 VSS.n648 VSS.t4 22.4954
R2538 VSS.n163 VSS.n162 21.9795
R2539 VSS.n427 VSS.n194 21.8527
R2540 VSS.n453 VSS.t0 21.8527
R2541 VSS.n863 VSS.t4 21.21
R2542 VSS.n63 VSS.t5 21.075
R2543 VSS.n919 VSS.n37 20.4805
R2544 VSS.n451 VSS.n19 19.22
R2545 VSS.n924 VSS.n33 16.4783
R2546 VSS.n336 VSS.n282 16.2346
R2547 VSS.n588 VSS.n587 16.2346
R2548 VSS.n412 VSS.n411 16.0785
R2549 VSS.n388 VSS.n192 16.0683
R2550 VSS.n640 VSS.n58 16.0683
R2551 VSS.n278 VSS.n190 15.9225
R2552 VSS.n194 VSS.n193 15.4256
R2553 VSS.n460 VSS.t8 15.4256
R2554 VSS.n638 VSS.n88 15.4256
R2555 VSS.n960 VSS.n20 15.2981
R2556 VSS.n587 VSS.n487 14.9859
R2557 VSS.n284 VSS.n282 14.9859
R2558 VSS.n970 VSS.n969 14.9347
R2559 VSS.n27 VSS.n25 14.8938
R2560 VSS.n23 VSS.n22 14.8938
R2561 VSS.n963 VSS.n15 14.7829
R2562 VSS.n855 VSS.n654 14.4151
R2563 VSS.n662 VSS.n656 14.4151
R2564 VSS.n332 VSS.n282 14.0493
R2565 VSS.n391 VSS.n390 13.7371
R2566 VSS.n645 VSS.n644 13.7371
R2567 VSS.n661 VSS.n660 13.7371
R2568 VSS.n398 VSS.n397 13.4405
R2569 VSS.n587 VSS.n586 13.1127
R2570 VSS.n438 VSS.n437 12.8547
R2571 VSS.n484 VSS.n483 12.8547
R2572 VSS.n167 VSS.n166 12.6288
R2573 VSS.n165 VSS.n162 12.6288
R2574 VSS.n166 VSS.n130 12.6288
R2575 VSS.n135 VSS.n131 12.6288
R2576 VSS.n137 VSS.n131 12.6288
R2577 VSS.n895 VSS.n48 12.6288
R2578 VSS.n893 VSS.n49 12.6288
R2579 VSS.n889 VSS.n52 12.6288
R2580 VSS.n882 VSS.n51 12.6288
R2581 VSS.n890 VSS.n48 12.6288
R2582 VSS.n894 VSS.n893 12.6288
R2583 VSS.n889 VSS.n888 12.6288
R2584 VSS.n884 VSS.n51 12.6288
R2585 VSS.n911 VSS.n41 12.6288
R2586 VSS.n907 VSS.n40 12.6288
R2587 VSS.n903 VSS.n39 12.6288
R2588 VSS.n38 VSS.n37 12.6288
R2589 VSS.n42 VSS.n41 12.6288
R2590 VSS.n910 VSS.n40 12.6288
R2591 VSS.n906 VSS.n39 12.6288
R2592 VSS.n902 VSS.n38 12.6288
R2593 VSS.n159 VSS.n132 11.7353
R2594 VSS.n159 VSS.n158 11.7353
R2595 VSS.n172 VSS.n129 11.3115
R2596 VSS.n134 VSS.n129 11.3115
R2597 VSS.n172 VSS.n171 11.2946
R2598 VSS.n464 VSS.n463 11.2395
R2599 VSS.n463 VSS.n462 11.2395
R2600 VSS.n462 VSS.n114 11.2395
R2601 VSS.n486 VSS.n114 11.2395
R2602 VSS.n487 VSS.n486 11.2395
R2603 VSS.n284 VSS.n283 11.2395
R2604 VSS.n283 VSS.n178 11.2395
R2605 VSS.n448 VSS.n178 11.2395
R2606 VSS.n449 VSS.n448 11.2395
R2607 VSS.n450 VSS.n449 11.2395
R2608 VSS.n440 VSS.n183 11.2395
R2609 VSS.n441 VSS.n440 11.2395
R2610 VSS.n444 VSS.n441 11.2395
R2611 VSS.n444 VSS.n443 11.2395
R2612 VSS.n443 VSS.n442 11.2395
R2613 VSS.n442 VSS.n125 11.2395
R2614 VSS.n469 VSS.n125 11.2395
R2615 VSS.n470 VSS.n469 11.2395
R2616 VSS.n472 VSS.n470 11.2395
R2617 VSS.n472 VSS.n471 11.2395
R2618 VSS.n471 VSS.n92 11.2395
R2619 VSS.n636 VSS.n92 11.2395
R2620 VSS.n385 VSS.n384 11.2395
R2621 VSS.n384 VSS.n383 11.2395
R2622 VSS.n383 VSS.n382 11.2395
R2623 VSS.n382 VSS.n380 11.2395
R2624 VSS.n380 VSS.n377 11.2395
R2625 VSS.n377 VSS.n376 11.2395
R2626 VSS.n376 VSS.n373 11.2395
R2627 VSS.n373 VSS.n372 11.2395
R2628 VSS.n372 VSS.n369 11.2395
R2629 VSS.n369 VSS.n368 11.2395
R2630 VSS.n368 VSS.n365 11.2395
R2631 VSS.n365 VSS.n364 11.2395
R2632 VSS.n364 VSS.n361 11.2395
R2633 VSS.n361 VSS.n360 11.2395
R2634 VSS.n360 VSS.n357 11.2395
R2635 VSS.n357 VSS.n356 11.2395
R2636 VSS.n356 VSS.n353 11.2395
R2637 VSS.n353 VSS.n352 11.2395
R2638 VSS.n352 VSS.n349 11.2395
R2639 VSS.n349 VSS.n348 11.2395
R2640 VSS.n348 VSS.n345 11.2395
R2641 VSS.n345 VSS.n344 11.2395
R2642 VSS.n344 VSS.n341 11.2395
R2643 VSS.n341 VSS.n340 11.2395
R2644 VSS.n340 VSS.n337 11.2395
R2645 VSS.n337 VSS.n336 11.2395
R2646 VSS.n635 VSS.n634 11.2395
R2647 VSS.n630 VSS.n629 11.2395
R2648 VSS.n629 VSS.n628 11.2395
R2649 VSS.n628 VSS.n96 11.2395
R2650 VSS.n623 VSS.n96 11.2395
R2651 VSS.n623 VSS.n622 11.2395
R2652 VSS.n622 VSS.n621 11.2395
R2653 VSS.n621 VSS.n99 11.2395
R2654 VSS.n616 VSS.n99 11.2395
R2655 VSS.n616 VSS.n615 11.2395
R2656 VSS.n615 VSS.n614 11.2395
R2657 VSS.n614 VSS.n102 11.2395
R2658 VSS.n609 VSS.n102 11.2395
R2659 VSS.n609 VSS.n608 11.2395
R2660 VSS.n608 VSS.n607 11.2395
R2661 VSS.n607 VSS.n105 11.2395
R2662 VSS.n602 VSS.n105 11.2395
R2663 VSS.n602 VSS.n601 11.2395
R2664 VSS.n601 VSS.n600 11.2395
R2665 VSS.n600 VSS.n108 11.2395
R2666 VSS.n595 VSS.n108 11.2395
R2667 VSS.n595 VSS.n594 11.2395
R2668 VSS.n594 VSS.n593 11.2395
R2669 VSS.n593 VSS.n111 11.2395
R2670 VSS.n588 VSS.n111 11.2395
R2671 VSS.n425 VSS.n424 10.6151
R2672 VSS.n424 VSS.n423 10.6151
R2673 VSS.n423 VSS.n392 10.6151
R2674 VSS.n413 VSS.n412 10.6151
R2675 VSS.n332 VSS.n331 10.6151
R2676 VSS.n331 VSS.n328 10.6151
R2677 VSS.n328 VSS.n327 10.6151
R2678 VSS.n327 VSS.n324 10.6151
R2679 VSS.n324 VSS.n323 10.6151
R2680 VSS.n323 VSS.n320 10.6151
R2681 VSS.n320 VSS.n319 10.6151
R2682 VSS.n319 VSS.n316 10.6151
R2683 VSS.n316 VSS.n315 10.6151
R2684 VSS.n315 VSS.n312 10.6151
R2685 VSS.n312 VSS.n311 10.6151
R2686 VSS.n311 VSS.n308 10.6151
R2687 VSS.n308 VSS.n307 10.6151
R2688 VSS.n307 VSS.n304 10.6151
R2689 VSS.n304 VSS.n303 10.6151
R2690 VSS.n303 VSS.n300 10.6151
R2691 VSS.n300 VSS.n299 10.6151
R2692 VSS.n299 VSS.n296 10.6151
R2693 VSS.n296 VSS.n295 10.6151
R2694 VSS.n295 VSS.n292 10.6151
R2695 VSS.n292 VSS.n291 10.6151
R2696 VSS.n291 VSS.n288 10.6151
R2697 VSS.n288 VSS.n287 10.6151
R2698 VSS.n287 VSS.n197 10.6151
R2699 VSS.n390 VSS.n198 10.6151
R2700 VSS.n237 VSS.n198 10.6151
R2701 VSS.n240 VSS.n237 10.6151
R2702 VSS.n241 VSS.n240 10.6151
R2703 VSS.n244 VSS.n241 10.6151
R2704 VSS.n245 VSS.n244 10.6151
R2705 VSS.n248 VSS.n245 10.6151
R2706 VSS.n249 VSS.n248 10.6151
R2707 VSS.n252 VSS.n249 10.6151
R2708 VSS.n253 VSS.n252 10.6151
R2709 VSS.n256 VSS.n253 10.6151
R2710 VSS.n257 VSS.n256 10.6151
R2711 VSS.n260 VSS.n257 10.6151
R2712 VSS.n261 VSS.n260 10.6151
R2713 VSS.n264 VSS.n261 10.6151
R2714 VSS.n265 VSS.n264 10.6151
R2715 VSS.n268 VSS.n265 10.6151
R2716 VSS.n269 VSS.n268 10.6151
R2717 VSS.n272 VSS.n269 10.6151
R2718 VSS.n273 VSS.n272 10.6151
R2719 VSS.n276 VSS.n273 10.6151
R2720 VSS.n277 VSS.n276 10.6151
R2721 VSS.n278 VSS.n277 10.6151
R2722 VSS.n431 VSS.n430 10.6151
R2723 VSS.n435 VSS.n431 10.6151
R2724 VSS.n435 VSS.n434 10.6151
R2725 VSS.n434 VSS.n433 10.6151
R2726 VSS.n433 VSS.n173 10.6151
R2727 VSS.n455 VSS.n173 10.6151
R2728 VSS.n456 VSS.n455 10.6151
R2729 VSS.n458 VSS.n119 10.6151
R2730 VSS.n477 VSS.n119 10.6151
R2731 VSS.n478 VSS.n477 10.6151
R2732 VSS.n481 VSS.n478 10.6151
R2733 VSS.n481 VSS.n480 10.6151
R2734 VSS.n480 VSS.n479 10.6151
R2735 VSS.n479 VSS.n75 10.6151
R2736 VSS.n646 VSS.n645 10.6151
R2737 VSS.n646 VSS.n64 10.6151
R2738 VSS.n865 VSS.n65 10.6151
R2739 VSS.n660 VSS.n65 10.6151
R2740 VSS.n852 VSS.n710 10.6151
R2741 VSS.n852 VSS.n851 10.6151
R2742 VSS.n851 VSS.n850 10.6151
R2743 VSS.n850 VSS.n847 10.6151
R2744 VSS.n847 VSS.n846 10.6151
R2745 VSS.n846 VSS.n843 10.6151
R2746 VSS.n843 VSS.n842 10.6151
R2747 VSS.n842 VSS.n839 10.6151
R2748 VSS.n839 VSS.n838 10.6151
R2749 VSS.n838 VSS.n835 10.6151
R2750 VSS.n835 VSS.n834 10.6151
R2751 VSS.n834 VSS.n831 10.6151
R2752 VSS.n831 VSS.n830 10.6151
R2753 VSS.n830 VSS.n827 10.6151
R2754 VSS.n827 VSS.n826 10.6151
R2755 VSS.n826 VSS.n823 10.6151
R2756 VSS.n823 VSS.n822 10.6151
R2757 VSS.n822 VSS.n819 10.6151
R2758 VSS.n819 VSS.n818 10.6151
R2759 VSS.n818 VSS.n815 10.6151
R2760 VSS.n815 VSS.n814 10.6151
R2761 VSS.n814 VSS.n811 10.6151
R2762 VSS.n811 VSS.n810 10.6151
R2763 VSS.n810 VSS.n807 10.6151
R2764 VSS.n807 VSS.n806 10.6151
R2765 VSS.n806 VSS.n803 10.6151
R2766 VSS.n803 VSS.n802 10.6151
R2767 VSS.n802 VSS.n799 10.6151
R2768 VSS.n799 VSS.n798 10.6151
R2769 VSS.n798 VSS.n795 10.6151
R2770 VSS.n795 VSS.n794 10.6151
R2771 VSS.n794 VSS.n791 10.6151
R2772 VSS.n791 VSS.n790 10.6151
R2773 VSS.n790 VSS.n787 10.6151
R2774 VSS.n787 VSS.n786 10.6151
R2775 VSS.n786 VSS.n783 10.6151
R2776 VSS.n783 VSS.n782 10.6151
R2777 VSS.n782 VSS.n779 10.6151
R2778 VSS.n779 VSS.n778 10.6151
R2779 VSS.n778 VSS.n775 10.6151
R2780 VSS.n775 VSS.n774 10.6151
R2781 VSS.n774 VSS.n771 10.6151
R2782 VSS.n771 VSS.n770 10.6151
R2783 VSS.n770 VSS.n767 10.6151
R2784 VSS.n767 VSS.n766 10.6151
R2785 VSS.n766 VSS.n763 10.6151
R2786 VSS.n763 VSS.n762 10.6151
R2787 VSS.n762 VSS.n759 10.6151
R2788 VSS.n759 VSS.n758 10.6151
R2789 VSS.n758 VSS.n755 10.6151
R2790 VSS.n755 VSS.n754 10.6151
R2791 VSS.n754 VSS.n751 10.6151
R2792 VSS.n751 VSS.n750 10.6151
R2793 VSS.n750 VSS.n747 10.6151
R2794 VSS.n747 VSS.n746 10.6151
R2795 VSS.n746 VSS.n743 10.6151
R2796 VSS.n743 VSS.n742 10.6151
R2797 VSS.n742 VSS.n739 10.6151
R2798 VSS.n739 VSS.n738 10.6151
R2799 VSS.n738 VSS.n735 10.6151
R2800 VSS.n735 VSS.n734 10.6151
R2801 VSS.n734 VSS.n731 10.6151
R2802 VSS.n731 VSS.n730 10.6151
R2803 VSS.n730 VSS.n727 10.6151
R2804 VSS.n727 VSS.n726 10.6151
R2805 VSS.n726 VSS.n723 10.6151
R2806 VSS.n723 VSS.n722 10.6151
R2807 VSS.n722 VSS.n719 10.6151
R2808 VSS.n719 VSS.n718 10.6151
R2809 VSS.n718 VSS.n715 10.6151
R2810 VSS.n715 VSS.n714 10.6151
R2811 VSS.n714 VSS.n711 10.6151
R2812 VSS.n670 VSS.n669 10.6151
R2813 VSS.n669 VSS.n668 10.6151
R2814 VSS.n668 VSS.n665 10.6151
R2815 VSS.n665 VSS.n664 10.6151
R2816 VSS.n651 VSS.n71 10.6151
R2817 VSS.n652 VSS.n651 10.6151
R2818 VSS.n861 VSS.n652 10.6151
R2819 VSS.n861 VSS.n860 10.6151
R2820 VSS.n860 VSS.n859 10.6151
R2821 VSS.n586 VSS.n488 10.6151
R2822 VSS.n489 VSS.n488 10.6151
R2823 VSS.n579 VSS.n489 10.6151
R2824 VSS.n579 VSS.n578 10.6151
R2825 VSS.n578 VSS.n577 10.6151
R2826 VSS.n577 VSS.n491 10.6151
R2827 VSS.n572 VSS.n491 10.6151
R2828 VSS.n572 VSS.n571 10.6151
R2829 VSS.n571 VSS.n570 10.6151
R2830 VSS.n570 VSS.n494 10.6151
R2831 VSS.n565 VSS.n494 10.6151
R2832 VSS.n565 VSS.n564 10.6151
R2833 VSS.n564 VSS.n563 10.6151
R2834 VSS.n563 VSS.n497 10.6151
R2835 VSS.n558 VSS.n497 10.6151
R2836 VSS.n558 VSS.n557 10.6151
R2837 VSS.n557 VSS.n556 10.6151
R2838 VSS.n556 VSS.n500 10.6151
R2839 VSS.n551 VSS.n500 10.6151
R2840 VSS.n551 VSS.n550 10.6151
R2841 VSS.n550 VSS.n549 10.6151
R2842 VSS.n549 VSS.n503 10.6151
R2843 VSS.n544 VSS.n503 10.6151
R2844 VSS.n544 VSS.n543 10.6151
R2845 VSS.n543 VSS.n542 10.6151
R2846 VSS.n542 VSS.n506 10.6151
R2847 VSS.n537 VSS.n506 10.6151
R2848 VSS.n537 VSS.n536 10.6151
R2849 VSS.n536 VSS.n535 10.6151
R2850 VSS.n535 VSS.n509 10.6151
R2851 VSS.n530 VSS.n529 10.6151
R2852 VSS.n529 VSS.n528 10.6151
R2853 VSS.n528 VSS.n513 10.6151
R2854 VSS.n523 VSS.n513 10.6151
R2855 VSS.n523 VSS.n522 10.6151
R2856 VSS.n522 VSS.n521 10.6151
R2857 VSS.n521 VSS.n516 10.6151
R2858 VSS.n516 VSS.n55 10.6151
R2859 VSS.n877 VSS.n56 10.6151
R2860 VSS.n59 VSS.n56 10.6151
R2861 VSS.n870 VSS.n59 10.6151
R2862 VSS.n870 VSS.n869 10.6151
R2863 VSS.n82 VSS.n61 10.6151
R2864 VSS.n83 VSS.n82 10.6151
R2865 VSS.n84 VSS.n83 10.6151
R2866 VSS.n960 VSS.n959 10.6151
R2867 VSS.n959 VSS.n958 10.6151
R2868 VSS.n958 VSS.n957 10.6151
R2869 VSS.n957 VSS.n955 10.6151
R2870 VSS.n955 VSS.n952 10.6151
R2871 VSS.n950 VSS.n947 10.6151
R2872 VSS.n947 VSS.n946 10.6151
R2873 VSS.n946 VSS.n2 10.6151
R2874 VSS.n966 VSS.n3 10.6151
R2875 VSS.n28 VSS.n3 10.6151
R2876 VSS.n31 VSS.n28 10.6151
R2877 VSS.n936 VSS.n933 10.6151
R2878 VSS.n933 VSS.n932 10.6151
R2879 VSS.n932 VSS.n929 10.6151
R2880 VSS.n402 VSS.n32 10.6151
R2881 VSS.n403 VSS.n402 10.6151
R2882 VSS.n406 VSS.n403 10.6151
R2883 VSS.n407 VSS.n406 10.6151
R2884 VSS.n410 VSS.n407 10.6151
R2885 VSS.n419 VSS.n418 10.2839
R2886 VSS.t1 VSS.n116 10.2839
R2887 VSS.n951 VSS.n950 9.99074
R2888 VSS.n425 VSS.n391 9.67855
R2889 VSS.n710 VSS.n653 9.67855
R2890 VSS.n670 VSS.n62 9.52245
R2891 VSS.n158 VSS.n157 9.49615
R2892 VSS.n880 VSS.n879 9.49615
R2893 VSS.n920 VSS.n36 9.49615
R2894 VSS.n413 VSS.n398 9.36635
R2895 VSS.n937 VSS.n31 9.36635
R2896 VSS.n891 VSS.n45 9.35118
R2897 VSS.n916 VSS.n915 9.35118
R2898 VSS.n968 VSS.n0 9.33091
R2899 VSS.n927 VSS.n926 9.33091
R2900 VSS.n939 VSS.n938 9.30726
R2901 VSS.n944 VSS.n943 9.30726
R2902 VSS.n397 VSS.n394 9.30726
R2903 VSS.n397 VSS.n396 9.30726
R2904 VSS.n157 VSS.n132 9.3005
R2905 VSS.n138 VSS.n137 9.3005
R2906 VSS.n168 VSS.n167 9.3005
R2907 VSS.n169 VSS.n130 9.3005
R2908 VSS.n171 VSS.n170 9.3005
R2909 VSS.n136 VSS.n135 9.3005
R2910 VSS.n134 VSS.n133 9.3005
R2911 VSS.n172 VSS.n128 9.3005
R2912 VSS.n165 VSS.n164 9.3005
R2913 VSS.n881 VSS.n880 9.3005
R2914 VSS.n883 VSS.n882 9.3005
R2915 VSS.n896 VSS.n895 9.3005
R2916 VSS.n894 VSS.n47 9.3005
R2917 VSS.n53 VSS.n49 9.3005
R2918 VSS.n888 VSS.n887 9.3005
R2919 VSS.n886 VSS.n52 9.3005
R2920 VSS.n885 VSS.n884 9.3005
R2921 VSS.n890 VSS.n46 9.3005
R2922 VSS.n920 VSS.n919 9.3005
R2923 VSS.n37 VSS.n35 9.3005
R2924 VSS.n912 VSS.n911 9.3005
R2925 VSS.n910 VSS.n909 9.3005
R2926 VSS.n908 VSS.n907 9.3005
R2927 VSS.n906 VSS.n905 9.3005
R2928 VSS.n904 VSS.n903 9.3005
R2929 VSS.n902 VSS.n901 9.3005
R2930 VSS.n43 VSS.n42 9.3005
R2931 VSS.n512 VSS.n509 9.05416
R2932 VSS.n879 VSS.n50 8.99803
R2933 VSS.n881 VSS.n50 8.99803
R2934 VSS.n918 VSS.n36 8.77968
R2935 VSS.n919 VSS.n918 8.77968
R2936 VSS.n464 VSS.n20 8.42977
R2937 VSS.n643 VSS.n76 8.42977
R2938 VSS.n430 VSS.n190 8.11757
R2939 VSS.n54 VSS.n34 7.9105
R2940 VSS.n922 VSS.n921 7.9105
R2941 VSS.n446 VSS.n180 7.71303
R2942 VSS.n475 VSS.n474 7.71303
R2943 VSS.n892 VSS.t12 7.5005
R2944 VSS.n892 VSS.t11 7.5005
R2945 VSS.n917 VSS.t9 7.5005
R2946 VSS.n917 VSS.t10 7.5005
R2947 VSS.n967 VSS.n966 7.49318
R2948 VSS.n93 VSS.n71 7.33709
R2949 VSS.n859 VSS.n653 7.33709
R2950 VSS.n927 VSS.n33 7.17833
R2951 VSS.n963 VSS.t0 7.07032
R2952 VSS.n634 VSS.n93 7.02489
R2953 VSS.n878 VSS.n55 6.86879
R2954 VSS.n644 VSS.n643 6.86879
R2955 VSS.n411 VSS.n410 6.86879
R2956 VSS.n428 VSS.n427 6.42761
R2957 VSS.n193 VSS.n185 6.42761
R2958 VSS.n437 VSS.n187 6.42761
R2959 VSS.n420 VSS.n419 6.42761
R2960 VSS.n416 VSS.n180 6.42761
R2961 VSS.n414 VSS.n175 6.42761
R2962 VSS.n458 VSS.n457 6.4005
R2963 VSS.n868 VSS.n61 5.93221
R2964 VSS.n969 VSS.n968 5.63473
R2965 VSS.n929 VSS.n928 5.62001
R2966 VSS.n938 VSS.n27 5.58708
R2967 VSS.n944 VSS.n22 5.58708
R2968 VSS.n866 VSS.n64 5.46391
R2969 VSS.n866 VSS.n865 5.15172
R2970 VSS.n420 VSS.t6 5.14219
R2971 VSS.n415 VSS.n414 5.14219
R2972 VSS.n466 VSS.n121 5.14219
R2973 VSS.n928 VSS.n32 4.99562
R2974 VSS.n869 VSS.n868 4.68343
R2975 VSS.n970 VSS.n1 4.57113
R2976 VSS.n925 VSS.n924 4.57113
R2977 VSS.n145 VSS.n144 4.55664
R2978 VSS.n940 VSS.n25 4.55421
R2979 VSS.n940 VSS.n939 4.55421
R2980 VSS.n942 VSS.n23 4.55421
R2981 VSS.n943 VSS.n942 4.55421
R2982 VSS.n163 VSS.n44 4.55421
R2983 VSS.n161 VSS.n44 4.55421
R2984 VSS.n898 VSS.n45 4.55421
R2985 VSS.n898 VSS.n897 4.55421
R2986 VSS.n915 VSS.n914 4.55421
R2987 VSS.n914 VSS.n913 4.55421
R2988 VSS.n395 VSS.n394 4.55421
R2989 VSS.n396 VSS.n395 4.55421
R2990 VSS.n926 VSS.n925 4.55419
R2991 VSS.n1 VSS.n0 4.55419
R2992 VSS.n160 VSS.t14 4.5005
R2993 VSS.n143 VSS.n142 4.5005
R2994 VSS.n149 VSS.n148 4.5005
R2995 VSS.n151 VSS.n150 4.5005
R2996 VSS.n156 VSS.n155 4.5005
R2997 VSS.n457 VSS.n456 4.21513
R2998 VSS.n630 VSS.n93 4.21513
R2999 VSS.n391 VSS.n197 3.90294
R3000 VSS.n644 VSS.n75 3.90294
R3001 VSS.n878 VSS.n877 3.74684
R3002 VSS.n155 VSS.n34 3.74068
R3003 VSS.n146 VSS.n145 3.4575
R3004 VSS.n154 VSS.n153 3.4575
R3005 VSS.n153 VSS.n152 3.4105
R3006 VSS.n141 VSS.n140 3.4105
R3007 VSS.n147 VSS.n146 3.4105
R3008 VSS.n664 VSS.n661 3.27855
R3009 VSS.n967 VSS.n2 3.12245
R3010 VSS.n453 VSS.n452 2.57134
R3011 VSS.n467 VSS.n460 2.57134
R3012 VSS.n150 VSS.n139 2.31781
R3013 VSS.n84 VSS.n76 2.18587
R3014 VSS.n942 VSS.n941 2.03865
R3015 VSS.n899 VSS.n44 2.02572
R3016 VSS.n923 VSS.n1 2.01343
R3017 VSS.n925 VSS.n923 1.68678
R3018 VSS.n941 VSS.n940 1.68615
R3019 VSS.n899 VSS.n898 1.68615
R3020 VSS.n914 VSS.n900 1.68615
R3021 VSS.n395 VSS.n24 1.68615
R3022 VSS.n530 VSS.n512 1.56148
R3023 VSS.n398 VSS.n392 1.24928
R3024 VSS.n450 VSS.n20 1.24928
R3025 VSS.n937 VSS.n936 1.24928
R3026 VSS.n867 VSS.n63 1.2063
R3027 VSS.n711 VSS.n62 1.09318
R3028 VSS.n155 VSS.n154 0.796962
R3029 VSS.n144 VSS.n63 0.7755
R3030 VSS.n952 VSS.n951 0.62489
R3031 VSS.n923 VSS.n922 0.512212
R3032 VSS.n900 VSS.n899 0.354175
R3033 VSS.n941 VSS.n24 0.34125
R3034 VSS.n922 VSS.n34 0.34125
R3035 VSS.n900 VSS.n24 0.328325
R3036 VSS.n169 VSS.n168 0.196152
R3037 VSS.n170 VSS.n169 0.196152
R3038 VSS.n170 VSS.n128 0.196152
R3039 VSS.n136 VSS.n133 0.196152
R3040 VSS.n896 VSS.n47 0.196152
R3041 VSS.n53 VSS.n47 0.196152
R3042 VSS.n887 VSS.n53 0.196152
R3043 VSS.n886 VSS.n885 0.196152
R3044 VSS.n912 VSS.n909 0.196152
R3045 VSS.n909 VSS.n908 0.196152
R3046 VSS.n908 VSS.n905 0.196152
R3047 VSS.n904 VSS.n901 0.196152
R3048 VSS VSS.n128 0.149957
R3049 VSS.n887 VSS 0.149957
R3050 VSS.n905 VSS 0.149957
R3051 VSS.n138 VSS.n136 0.140391
R3052 VSS.n885 VSS.n883 0.140391
R3053 VSS.n901 VSS.n35 0.140391
R3054 VSS.n145 VSS.n143 0.1005
R3055 VSS.n396 VSS 0.0950946
R3056 VSS.n157 VSS.n156 0.0901739
R3057 VSS.n880 VSS.n54 0.0901739
R3058 VSS.n921 VSS.n920 0.0901739
R3059 VSS.n943 VSS 0.0883378
R3060 VSS.n168 VSS.n161 0.0870159
R3061 VSS.n897 VSS.n896 0.0870159
R3062 VSS.n913 VSS.n912 0.0870159
R3063 VSS.n148 VSS.n147 0.0755
R3064 VSS.n152 VSS.n151 0.0755
R3065 VSS.n152 VSS.n139 0.0749345
R3066 VSS.n164 VSS.n163 0.0714459
R3067 VSS.n46 VSS.n45 0.0714459
R3068 VSS.n915 VSS.n43 0.0714459
R3069 VSS.n149 VSS.n142 0.0682966
R3070 VSS.n939 VSS 0.063
R3071 VSS VSS.n149 0.0619407
R3072 VSS VSS.n0 0.0613108
R3073 VSS.n926 VSS 0.0613108
R3074 VSS.n154 VSS.n139 0.0509781
R3075 VSS.n148 VSS.n141 0.0505
R3076 VSS.n151 VSS.n141 0.0505
R3077 VSS.n146 VSS.n140 0.0475
R3078 VSS.n153 VSS.n140 0.0475
R3079 VSS.n133 VSS 0.0466957
R3080 VSS VSS.n886 0.0466957
R3081 VSS VSS.n904 0.0466957
R3082 VSS VSS.n25 0.0461081
R3083 VSS.n164 VSS.n161 0.0376622
R3084 VSS.n897 VSS.n46 0.0376622
R3085 VSS.n913 VSS.n43 0.0376622
R3086 VSS VSS.n970 0.0309054
R3087 VSS.n924 VSS 0.0309054
R3088 VSS.n147 VSS.n143 0.0255
R3089 VSS.n23 VSS 0.0207703
R3090 VSS.n156 VSS.n138 0.0155
R3091 VSS.n883 VSS.n54 0.0155
R3092 VSS.n921 VSS.n35 0.0155
R3093 VSS VSS.n394 0.0140135
R3094 VSS.n144 VSS.n142 0.0121525
R3095 VSS.n150 VSS 0.00685593
R3096 vdi.n0 vdi.t10 257
R3097 vdi.t10 vdi.n1 257
R3098 vdi.n0 vdi.n1 27.1064
R3099 vdi.n2 vdi.n3 4.5005
R3100 vdi.n4 vdi.n223 4.5005
R3101 vdi.n2 vdi.n0 9.30441
R3102 vdi vdi.n2 0.0766719
R3103 vdi vdi.n4 0.0493281
R3104 vdi.n4 vdi.n1 9.31222
R3105 vdi.n3 vdi.n223 0.1255
R3106 vdi.n3 vdi.n182 6.51508
R3107 vdi.n184 vdi.n183 9.3005
R3108 vdi.n185 vdi.n188 9.3005
R3109 vdi.n190 vdi.n189 9.3005
R3110 vdi.n191 vdi.n192 9.3005
R3111 vdi.n197 vdi.n196 9.3005
R3112 vdi.n198 vdi.n199 9.3005
R3113 vdi.n204 vdi.n203 9.3005
R3114 vdi.n205 vdi.n206 9.3005
R3115 vdi.n211 vdi.n210 9.3005
R3116 vdi.n212 vdi.n213 9.3005
R3117 vdi.n219 vdi.n218 9.3005
R3118 vdi.n182 vdi 0.130917
R3119 vdi vdi.n188 0.043
R3120 vdi.n188 vdi.n184 0.1805
R3121 vdi.n184 vdi.n195 0.3905
R3122 vdi.n195 vdi 0.138
R3123 vdi vdi.n192 0.043
R3124 vdi.n192 vdi.n190 0.1805
R3125 vdi.n190 vdi.n202 0.3905
R3126 vdi.n202 vdi 0.138
R3127 vdi vdi.n199 0.043
R3128 vdi.n199 vdi.n197 0.1805
R3129 vdi.n197 vdi.n209 0.3905
R3130 vdi.n209 vdi 0.138
R3131 vdi vdi.n206 0.043
R3132 vdi.n206 vdi.n204 0.1805
R3133 vdi.n204 vdi.n216 0.3905
R3134 vdi.n216 vdi 0.138
R3135 vdi vdi.n213 0.043
R3136 vdi.n213 vdi.n211 0.1805
R3137 vdi.n211 vdi.n222 0.3905
R3138 vdi.n222 vdi.n219 0.1805
R3139 vdi.n219 vdi 0.043
R3140 vdi vdi.n217 9.438
R3141 vdi.n218 vdi.n220 11.3247
R3142 vdi.n222 vdi.n220 23.0638
R3143 vdi.n218 vdi.n217 27.1064
R3144 vdi.n220 vdi.n221 77.1778
R3145 vdi.n221 vdi.n217 184.74
R3146 vdi.n221 vdi.t11 96.4005
R3147 vdi.n214 vdi.n212 11.3247
R3148 vdi.n216 vdi.n214 23.0638
R3149 vdi.n212 vdi.n210 27.1064
R3150 vdi.n214 vdi.n215 77.1778
R3151 vdi.n215 vdi.n210 184.74
R3152 vdi.n215 vdi.t12 96.4005
R3153 vdi.n207 vdi.n205 11.3247
R3154 vdi.n209 vdi.n207 23.0638
R3155 vdi.n205 vdi.n203 27.1064
R3156 vdi.n207 vdi.n208 77.1778
R3157 vdi.n208 vdi.n203 184.74
R3158 vdi.n208 vdi.t13 96.4005
R3159 vdi.n200 vdi.n198 11.3247
R3160 vdi.n202 vdi.n200 23.0638
R3161 vdi.n198 vdi.n196 27.1064
R3162 vdi.n200 vdi.n201 77.1778
R3163 vdi.n201 vdi.n196 184.74
R3164 vdi.n201 vdi.t14 96.4005
R3165 vdi.n193 vdi.n191 11.3247
R3166 vdi.n195 vdi.n193 23.0638
R3167 vdi.n191 vdi.n189 27.1064
R3168 vdi.n193 vdi.n194 77.1778
R3169 vdi.n194 vdi.n189 184.74
R3170 vdi.n194 vdi.t15 96.4005
R3171 vdi.n186 vdi.n185 11.3247
R3172 vdi.n182 vdi.n186 23.0638
R3173 vdi.n185 vdi.n183 27.1064
R3174 vdi.n186 vdi.n187 77.1778
R3175 vdi.n187 vdi.n183 184.74
R3176 vdi.n187 vdi.t16 96.4005
R3177 vdi.n223 vdi.n5 0.758327
R3178 vdi.n125 vdi.n126 4.5005
R3179 vdi.n128 vdi.n127 4.5005
R3180 vdi.n130 vdi.n131 4.5005
R3181 vdi.n132 vdi.n133 4.5005
R3182 vdi.n134 vdi.n135 4.5005
R3183 vdi.n136 vdi.n137 4.5005
R3184 vdi.n138 vdi.n139 4.5005
R3185 vdi.n140 vdi.n141 4.5005
R3186 vdi.n143 vdi.n142 4.5005
R3187 vdi.n144 vdi.n145 4.5005
R3188 vdi.n146 vdi.n147 4.5005
R3189 vdi.n148 vdi.n149 4.5005
R3190 vdi.n180 vdi.n181 4.5005
R3191 vdi.n5 vdi.n128 0.514316
R3192 vdi.n128 vdi.n126 0.1255
R3193 vdi.n126 vdi.n181 0.1255
R3194 vdi.n181 vdi.n149 0.1255
R3195 vdi.n149 vdi.n147 0.1255
R3196 vdi.n147 vdi.n145 0.1255
R3197 vdi.n145 vdi.n143 0.1255
R3198 vdi.n143 vdi.n141 0.1255
R3199 vdi.n141 vdi.n139 0.1255
R3200 vdi.n139 vdi.n137 0.1255
R3201 vdi.n137 vdi.n135 0.1255
R3202 vdi.n135 vdi.n133 0.1255
R3203 vdi.n133 vdi.n131 0.1255
R3204 vdi.n131 vdi.n129 4.6255
R3205 vdi.n151 vdi.n150 9.3005
R3206 vdi.n153 vdi.n152 9.3005
R3207 vdi.n155 vdi.n154 9.3005
R3208 vdi.n157 vdi.n156 9.3005
R3209 vdi.n159 vdi.n158 9.3005
R3210 vdi.n161 vdi.n160 9.3005
R3211 vdi.n163 vdi.n162 9.3005
R3212 vdi.n165 vdi.n164 9.3005
R3213 vdi.n167 vdi.n166 9.3005
R3214 vdi.n169 vdi.n168 9.3005
R3215 vdi.n171 vdi.n170 9.3005
R3216 vdi.n127 vdi.n151 0.113781
R3217 vdi.n151 vdi.n125 0.0122188
R3218 vdi.n125 vdi.n180 0.1255
R3219 vdi.n180 vdi.n153 0.00440625
R3220 vdi.n153 vdi.n148 0.121594
R3221 vdi.n148 vdi.n155 0.0200312
R3222 vdi.n155 vdi.n146 0.105969
R3223 vdi.n146 vdi.n157 0.0356562
R3224 vdi.n157 vdi.n144 0.0903438
R3225 vdi.n144 vdi.n159 0.0512812
R3226 vdi.n159 vdi 0.0337031
R3227 vdi vdi.n142 0.0415156
R3228 vdi.n142 vdi.n161 0.0669062
R3229 vdi.n161 vdi.n140 0.0590938
R3230 vdi.n140 vdi.n163 0.0825312
R3231 vdi.n163 vdi.n138 0.0434688
R3232 vdi.n138 vdi.n165 0.0981562
R3233 vdi.n165 vdi.n136 0.0278438
R3234 vdi.n136 vdi.n167 0.113781
R3235 vdi.n167 vdi.n134 0.0122188
R3236 vdi.n134 vdi.n132 0.1255
R3237 vdi.n132 vdi.n169 0.00440625
R3238 vdi.n169 vdi.n130 0.121594
R3239 vdi.n130 vdi.n171 0.0200312
R3240 vdi.n171 vdi.n129 0.105969
R3241 vdi.n129 vdi.n172 9.33566
R3242 vdi.n178 vdi.n179 285.877
R3243 vdi.n178 vdi.n150 13.2471
R3244 vdi.n179 vdi.n177 285.877
R3245 vdi.n177 vdi.n154 13.2471
R3246 vdi.n179 vdi.n176 285.877
R3247 vdi.n176 vdi.n158 13.2471
R3248 vdi.n179 vdi.n175 285.877
R3249 vdi.n175 vdi.n162 13.2471
R3250 vdi.n179 vdi.n174 285.877
R3251 vdi.n174 vdi.n166 13.2471
R3252 vdi.n179 vdi.n173 285.877
R3253 vdi.n173 vdi.n170 13.2471
R3254 vdi.n179 vdi.n172 585
R3255 vdi.n127 vdi.n178 22.5744
R3256 vdi.n150 vdi.n152 27.1064
R3257 vdi.n152 vdi.n177 13.2471
R3258 vdi.n154 vdi.n156 27.1064
R3259 vdi.n156 vdi.n176 13.2471
R3260 vdi.n158 vdi.n160 27.1064
R3261 vdi.n160 vdi.n175 13.2471
R3262 vdi.n162 vdi.n164 27.1064
R3263 vdi.n164 vdi.n174 13.2471
R3264 vdi.n166 vdi.n168 27.1064
R3265 vdi.n168 vdi.n173 13.2471
R3266 vdi.n170 vdi.n172 27.1064
R3267 vdi.n179 vdi.t3 9.8505
R3268 vdi.n179 vdi.t2 9.8505
R3269 vdi.n64 vdi.n63 3.4105
R3270 vdi.n5 vdi.n64 3.858
R3271 vdi.n64 vdi.n124 3.8768
R3272 vdi.n123 vdi.n120 4.5005
R3273 vdi.n123 vdi.n119 4.6255
R3274 vdi.n124 vdi.n123 0.745827
R3275 vdi.n119 vdi 0.102062
R3276 vdi vdi.n120 0.0239375
R3277 vdi.n121 vdi.n122 86.1871
R3278 vdi.n120 vdi.n121 21.9288
R3279 vdi.n119 vdi.n121 21.9445
R3280 vdi.n122 vdi.t6 30.0005
R3281 vdi.n122 vdi.t7 30.0005
R3282 vdi.n67 vdi.n66 4.5005
R3283 vdi.n69 vdi.n68 4.5005
R3284 vdi.n71 vdi.n70 4.5005
R3285 vdi.n73 vdi.n72 4.5005
R3286 vdi.n75 vdi.n74 4.5005
R3287 vdi.n77 vdi.n76 4.5005
R3288 vdi.n79 vdi.n78 4.5005
R3289 vdi.n81 vdi.n80 4.5005
R3290 vdi.n83 vdi.n82 4.5005
R3291 vdi.n85 vdi.n84 4.5005
R3292 vdi.n87 vdi.n86 4.5005
R3293 vdi.n89 vdi.n88 4.5005
R3294 vdi.n118 vdi.n117 4.5005
R3295 vdi.n124 vdi.n67 0.503906
R3296 vdi.n67 vdi.n69 0.098061
R3297 vdi.n69 vdi.n71 0.098061
R3298 vdi.n71 vdi.n73 0.098061
R3299 vdi.n73 vdi.n75 0.098061
R3300 vdi.n75 vdi.n77 0.098061
R3301 vdi.n77 vdi.n79 0.098061
R3302 vdi.n79 vdi.n81 0.098061
R3303 vdi.n81 vdi.n83 0.098061
R3304 vdi.n83 vdi.n85 0.098061
R3305 vdi.n85 vdi.n87 0.098061
R3306 vdi.n87 vdi.n89 0.098061
R3307 vdi.n89 vdi.n118 0.098061
R3308 vdi.n118 vdi.n65 4.59806
R3309 vdi.n91 vdi.n90 9.3005
R3310 vdi.n88 vdi.n92 9.3005
R3311 vdi.n94 vdi.n93 9.3005
R3312 vdi.n96 vdi.n95 9.3005
R3313 vdi.n98 vdi.n97 9.3005
R3314 vdi.n100 vdi.n99 9.3005
R3315 vdi.n102 vdi.n101 9.3005
R3316 vdi.n104 vdi.n103 9.3005
R3317 vdi.n106 vdi.n105 9.3005
R3318 vdi.n70 vdi.n107 9.3005
R3319 vdi.n109 vdi.n108 9.3005
R3320 vdi.n66 vdi.n109 0.109875
R3321 vdi.n109 vdi.n68 0.016125
R3322 vdi.n68 vdi.n70 0.1255
R3323 vdi.n70 vdi.n72 0.1255
R3324 vdi.n72 vdi.n106 0.016125
R3325 vdi.n106 vdi.n74 0.109875
R3326 vdi.n74 vdi.n104 0.03175
R3327 vdi.n104 vdi.n76 0.09425
R3328 vdi.n76 vdi.n102 0.047375
R3329 vdi.n102 vdi 0.0551875
R3330 vdi vdi.n78 0.0239375
R3331 vdi.n78 vdi.n100 0.063
R3332 vdi.n100 vdi.n80 0.063
R3333 vdi.n80 vdi.n98 0.078625
R3334 vdi.n98 vdi.n82 0.047375
R3335 vdi.n82 vdi.n96 0.09425
R3336 vdi.n96 vdi.n84 0.03175
R3337 vdi.n84 vdi.n94 0.109875
R3338 vdi.n94 vdi.n86 0.016125
R3339 vdi.n86 vdi.n88 0.1255
R3340 vdi.n88 vdi.n117 0.1255
R3341 vdi.n117 vdi.n91 0.016125
R3342 vdi.n91 vdi.n65 0.109875
R3343 vdi.n116 vdi.n115 285.877
R3344 vdi.n114 vdi.n116 285.877
R3345 vdi.n114 vdi.n108 13.2471
R3346 vdi.n116 vdi.n113 285.877
R3347 vdi.n113 vdi.n105 13.2471
R3348 vdi.n116 vdi.n112 285.877
R3349 vdi.n112 vdi.n101 13.2471
R3350 vdi.n116 vdi.n111 285.877
R3351 vdi.n111 vdi.n97 13.2471
R3352 vdi.n116 vdi.n110 285.877
R3353 vdi.n110 vdi.n93 13.2471
R3354 vdi.n116 vdi.n92 585
R3355 vdi.n90 vdi.n115 13.2471
R3356 vdi.n66 vdi.n114 22.5783
R3357 vdi.n108 vdi.n107 27.1064
R3358 vdi.n107 vdi.n113 13.2471
R3359 vdi.n105 vdi.n103 27.1064
R3360 vdi.n103 vdi.n112 13.2471
R3361 vdi.n101 vdi.n99 27.1064
R3362 vdi.n99 vdi.n111 13.2471
R3363 vdi.n97 vdi.n95 27.1064
R3364 vdi.n95 vdi.n110 13.2471
R3365 vdi.n93 vdi.n92 27.1064
R3366 vdi.n92 vdi.n90 27.1064
R3367 vdi.n115 vdi.n65 22.5783
R3368 vdi.n116 vdi.t4 9.8505
R3369 vdi.n116 vdi.t5 9.8505
R3370 vdi.n63 vdi.n61 3.03972
R3371 vdi.n61 vdi 0.0491236
R3372 vdi.n61 vdi.n62 97.1522
R3373 vdi.n62 vdi.t8 30.0005
R3374 vdi.n62 vdi.t9 30.0005
R3375 vdi.n7 vdi.n6 4.5005
R3376 vdi.n9 vdi.n8 4.5005
R3377 vdi.n12 vdi.n11 4.5005
R3378 vdi.n14 vdi.n13 4.5005
R3379 vdi.n16 vdi.n15 4.5005
R3380 vdi.n18 vdi.n17 4.5005
R3381 vdi.n20 vdi.n19 4.5005
R3382 vdi.n22 vdi.n21 4.5005
R3383 vdi.n24 vdi.n23 4.5005
R3384 vdi.n26 vdi.n25 4.5005
R3385 vdi.n28 vdi.n27 4.5005
R3386 vdi.n30 vdi.n29 4.5005
R3387 vdi.n60 vdi.n31 4.5005
R3388 vdi.n63 vdi.n9 0.503906
R3389 vdi.n9 vdi.n7 0.098061
R3390 vdi.n7 vdi.n60 0.098061
R3391 vdi.n60 vdi.n30 0.098061
R3392 vdi.n30 vdi.n28 0.098061
R3393 vdi.n28 vdi.n26 0.098061
R3394 vdi.n26 vdi.n24 0.098061
R3395 vdi.n24 vdi.n22 0.098061
R3396 vdi.n22 vdi.n20 0.098061
R3397 vdi.n20 vdi.n18 0.098061
R3398 vdi.n18 vdi.n16 0.098061
R3399 vdi.n16 vdi.n14 0.098061
R3400 vdi.n14 vdi.n12 0.098061
R3401 vdi.n12 vdi.n10 4.59806
R3402 vdi.n33 vdi.n32 9.3005
R3403 vdi.n31 vdi.n34 9.3005
R3404 vdi.n36 vdi.n35 9.3005
R3405 vdi.n38 vdi.n37 9.3005
R3406 vdi.n40 vdi.n39 9.3005
R3407 vdi.n42 vdi.n41 9.3005
R3408 vdi.n44 vdi.n43 9.3005
R3409 vdi.n46 vdi.n45 9.3005
R3410 vdi.n48 vdi.n47 9.3005
R3411 vdi.n13 vdi.n49 9.3005
R3412 vdi.n51 vdi.n50 9.3005
R3413 vdi.n8 vdi.n33 0.109875
R3414 vdi.n33 vdi.n6 0.016125
R3415 vdi.n6 vdi.n31 0.1255
R3416 vdi.n31 vdi.n29 0.1255
R3417 vdi.n29 vdi.n36 0.016125
R3418 vdi.n36 vdi.n27 0.109875
R3419 vdi.n27 vdi.n38 0.03175
R3420 vdi.n38 vdi.n25 0.09425
R3421 vdi.n25 vdi.n40 0.047375
R3422 vdi.n40 vdi 0.0551875
R3423 vdi vdi.n23 0.0239375
R3424 vdi.n23 vdi.n42 0.063
R3425 vdi.n42 vdi.n21 0.063
R3426 vdi.n21 vdi.n44 0.078625
R3427 vdi.n44 vdi.n19 0.047375
R3428 vdi.n19 vdi.n46 0.09425
R3429 vdi.n46 vdi.n17 0.03175
R3430 vdi.n17 vdi.n48 0.109875
R3431 vdi.n48 vdi.n15 0.016125
R3432 vdi.n15 vdi.n13 0.1255
R3433 vdi.n13 vdi.n11 0.1255
R3434 vdi.n11 vdi.n51 0.016125
R3435 vdi.n51 vdi.n10 0.109875
R3436 vdi.n10 vdi.n52 9.33175
R3437 vdi.n58 vdi.n59 285.877
R3438 vdi.n58 vdi.n32 13.2471
R3439 vdi.n59 vdi.n57 285.877
R3440 vdi.n57 vdi.n35 13.2471
R3441 vdi.n59 vdi.n56 285.877
R3442 vdi.n56 vdi.n39 13.2471
R3443 vdi.n59 vdi.n55 285.877
R3444 vdi.n55 vdi.n43 13.2471
R3445 vdi.n59 vdi.n54 285.877
R3446 vdi.n54 vdi.n47 13.2471
R3447 vdi.n59 vdi.n53 285.877
R3448 vdi.n53 vdi.n50 13.2471
R3449 vdi.n59 vdi.n52 585
R3450 vdi.n8 vdi.n58 22.5783
R3451 vdi.n32 vdi.n34 27.1064
R3452 vdi.n34 vdi.n57 13.2471
R3453 vdi.n35 vdi.n37 27.1064
R3454 vdi.n37 vdi.n56 13.2471
R3455 vdi.n39 vdi.n41 27.1064
R3456 vdi.n41 vdi.n55 13.2471
R3457 vdi.n43 vdi.n45 27.1064
R3458 vdi.n45 vdi.n54 13.2471
R3459 vdi.n47 vdi.n49 27.1064
R3460 vdi.n49 vdi.n53 13.2471
R3461 vdi.n50 vdi.n52 27.1064
R3462 vdi.n59 vdi.t0 9.8505
R3463 vdi.n59 vdi.t1 9.8505
R3464 vgp_self.n0 vgp_self.n1 185
R3465 vgp_self.n2 vgp_self.n3 12.6288
R3466 vgp_self.n3 vgp_self.n0 86.1871
R3467 vgp_self.n5 vgp_self.n6 12.6288
R3468 vgp_self.n0 vgp_self.n6 86.1871
R3469 vgp_self.n8 vgp_self.n9 12.6288
R3470 vgp_self.n0 vgp_self.n9 86.1871
R3471 vgp_self.n11 vgp_self.n12 12.6288
R3472 vgp_self.n0 vgp_self.n12 86.1871
R3473 vgp_self.n14 vgp_self.n15 12.6288
R3474 vgp_self.n0 vgp_self.n15 86.1871
R3475 vgp_self.n0 vgp_self.t4 7.5005
R3476 vgp_self.n0 vgp_self.t5 7.5005
R3477 vgp_self.n16 vgp_self.n2 9.3005
R3478 vgp_self.n17 vgp_self.n4 9.3005
R3479 vgp_self.n18 vgp_self.n5 9.3005
R3480 vgp_self.n19 vgp_self.n7 9.3005
R3481 vgp_self.n20 vgp_self.n8 9.3005
R3482 vgp_self.n21 vgp_self.n10 9.3005
R3483 vgp_self.n22 vgp_self.n11 9.3005
R3484 vgp_self.n23 vgp_self.n13 9.3005
R3485 vgp_self.n24 vgp_self.n14 9.3005
R3486 vgp_self.n15 vgp_self.n263 21.9288
R3487 vgp_self.n1 vgp_self.n2 27.1064
R3488 vgp_self.n3 vgp_self.n4 12.6288
R3489 vgp_self.n4 vgp_self.n5 27.1064
R3490 vgp_self.n6 vgp_self.n7 12.6288
R3491 vgp_self.n7 vgp_self.n8 27.1064
R3492 vgp_self.n9 vgp_self.n10 12.6288
R3493 vgp_self.n10 vgp_self.n11 27.1064
R3494 vgp_self.n12 vgp_self.n13 12.6288
R3495 vgp_self.n13 vgp_self.n14 27.1064
R3496 vgp_self.n20 vgp_self.n21 0.1805
R3497 vgp_self.n21 vgp_self.n22 0.1805
R3498 vgp_self.n22 vgp_self.n23 0.1805
R3499 vgp_self.n23 vgp_self.n24 0.1805
R3500 vgp_self.n24 vgp_self.n263 0.1805
R3501 vgp_self.n263 vgp_self.n25 0.603
R3502 vgp_self.n18 vgp_self.n26 0.0611776
R3503 vgp_self.n26 vgp_self.n19 0.0611758
R3504 vgp_self.n19 vgp_self.n20 0.144824
R3505 vgp_self vgp_self.n1 9.3055
R3506 vgp_self vgp_self.n16 0.1755
R3507 vgp_self.n16 vgp_self.n17 0.1805
R3508 vgp_self.n17 vgp_self.n18 0.144824
R3509 vgp_self.n26 vgp_self.n27 4.3631
R3510 vgp_self.n28 vgp_self.n27 3.9495
R3511 vgp_self.n30 vgp_self.n29 9.3005
R3512 vgp_self.n32 vgp_self.n31 9.3005
R3513 vgp_self.n28 vgp_self.n30 0.0611776
R3514 vgp_self.n32 vgp_self.n28 0.0611758
R3515 vgp_self.n35 vgp_self.n34 9.3005
R3516 vgp_self.n262 vgp_self.n36 9.3005
R3517 vgp_self vgp_self.n33 0.0305
R3518 vgp_self.n35 vgp_self.n33 0.1805
R3519 vgp_self.n262 vgp_self.n35 0.1805
R3520 vgp_self.n30 vgp_self.n262 0.144824
R3521 vgp_self.n261 vgp_self.n260 86.1871
R3522 vgp_self.n38 vgp_self.n37 9.3005
R3523 vgp_self.n40 vgp_self.n39 9.3005
R3524 vgp_self.n42 vgp_self.n41 9.3005
R3525 vgp_self.n44 vgp_self.n43 9.3005
R3526 vgp_self.n46 vgp_self.n45 9.3005
R3527 vgp_self.n255 vgp_self.n47 9.3005
R3528 vgp_self.n34 vgp_self.n260 12.6288
R3529 vgp_self.n261 vgp_self.n259 86.1871
R3530 vgp_self.n29 vgp_self.n259 12.6288
R3531 vgp_self.n261 vgp_self.n258 86.1871
R3532 vgp_self.n37 vgp_self.n258 12.6288
R3533 vgp_self.n261 vgp_self.n257 86.1871
R3534 vgp_self.n41 vgp_self.n257 12.6288
R3535 vgp_self.n256 vgp_self.n261 86.1871
R3536 vgp_self.n45 vgp_self.n256 12.6288
R3537 vgp_self.n261 vgp_self.n47 185
R3538 vgp_self.n33 vgp_self.n260 21.9288
R3539 vgp_self.n34 vgp_self.n36 27.1064
R3540 vgp_self.n36 vgp_self.n259 12.6288
R3541 vgp_self.n29 vgp_self.n31 27.1064
R3542 vgp_self.n31 vgp_self.n258 12.6288
R3543 vgp_self.n37 vgp_self.n39 27.1064
R3544 vgp_self.n39 vgp_self.n257 12.6288
R3545 vgp_self.n41 vgp_self.n43 27.1064
R3546 vgp_self.n43 vgp_self.n256 12.6288
R3547 vgp_self.n45 vgp_self.n47 27.1064
R3548 vgp_self.n261 vgp_self.t2 7.5005
R3549 vgp_self.n261 vgp_self.t3 7.5005
R3550 vgp_self.n38 vgp_self.n32 0.144824
R3551 vgp_self.n40 vgp_self.n38 0.1805
R3552 vgp_self.n42 vgp_self.n40 0.1805
R3553 vgp_self.n44 vgp_self.n42 0.1805
R3554 vgp_self.n46 vgp_self.n44 0.1805
R3555 vgp_self.n255 vgp_self.n46 0.1805
R3556 vgp_self.n48 vgp_self.n255 0.603
R3557 vgp_self.n48 vgp_self.n254 1.5005
R3558 vgp_self.n25 vgp_self.n48 1.5005
R3559 vgp_self.n50 vgp_self.n49 9.3005
R3560 vgp_self.n52 vgp_self.n51 9.3005
R3561 vgp_self.n54 vgp_self.n53 9.3005
R3562 vgp_self.n56 vgp_self.n55 9.3005
R3563 vgp_self.n58 vgp_self.n57 9.3005
R3564 vgp_self.n60 vgp_self.n59 9.3005
R3565 vgp_self.n52 vgp_self.n50 0.1805
R3566 vgp_self.n54 vgp_self.n52 0.1805
R3567 vgp_self.n56 vgp_self.n54 0.1805
R3568 vgp_self.n58 vgp_self.n56 0.1805
R3569 vgp_self.n60 vgp_self.n58 0.1805
R3570 vgp_self.n254 vgp_self.n60 0.603
R3571 vgp_self.n82 vgp_self.n81 9.3005
R3572 vgp_self.n84 vgp_self.n83 9.3005
R3573 vgp_self.n86 vgp_self.n85 9.3005
R3574 vgp_self.n88 vgp_self.n87 9.3005
R3575 vgp_self.n90 vgp_self.n89 9.3005
R3576 vgp_self.n92 vgp_self.n91 9.3005
R3577 vgp_self.n94 vgp_self.n93 9.3005
R3578 vgp_self.n95 vgp_self.n96 9.3005
R3579 vgp_self.n98 vgp_self.n97 9.3005
R3580 vgp_self.n100 vgp_self.n99 9.3005
R3581 vgp_self.n102 vgp_self.n101 9.3005
R3582 vgp_self.n111 vgp_self.n103 9.3005
R3583 vgp_self.n254 vgp_self.n80 0.533
R3584 vgp_self.n80 vgp_self.n82 0.1805
R3585 vgp_self.n82 vgp_self.n84 0.1805
R3586 vgp_self.n84 vgp_self.n86 0.1805
R3587 vgp_self.n86 vgp_self.n88 0.1805
R3588 vgp_self.n88 vgp_self.n90 0.1805
R3589 vgp_self.n90 vgp_self.n92 0.1805
R3590 vgp_self.n92 vgp_self.n94 0.1805
R3591 vgp_self.n94 vgp_self 0.138
R3592 vgp_self vgp_self.n96 0.043
R3593 vgp_self.n96 vgp_self.n98 0.1805
R3594 vgp_self.n98 vgp_self.n100 0.1805
R3595 vgp_self.n100 vgp_self.n102 0.1805
R3596 vgp_self.n102 vgp_self.n111 0.1805
R3597 vgp_self.n111 vgp_self.n253 0.2905
R3598 vgp_self.n114 vgp_self.n113 9.3005
R3599 vgp_self.n119 vgp_self.n118 9.3005
R3600 vgp_self.n120 vgp_self.n121 9.3005
R3601 vgp_self.n126 vgp_self.n125 9.3005
R3602 vgp_self.n128 vgp_self.n127 9.3005
R3603 vgp_self.n133 vgp_self.n132 9.3005
R3604 vgp_self.n134 vgp_self 9.3005
R3605 vgp_self.n139 vgp_self.n138 9.3005
R3606 vgp_self.n140 vgp_self.n141 9.3005
R3607 vgp_self.n146 vgp_self.n145 9.3005
R3608 vgp_self.n147 vgp_self.n148 9.3005
R3609 vgp_self.n153 vgp_self.n152 9.3005
R3610 vgp_self.n155 vgp_self.n154 9.3005
R3611 vgp_self.n159 vgp_self.n160 9.3005
R3612 vgp_self.n162 vgp_self.n161 9.3005
R3613 vgp_self.n167 vgp_self.n166 9.3005
R3614 vgp_self.n168 vgp_self 9.3005
R3615 vgp_self.n172 vgp_self.n173 9.3005
R3616 vgp_self.n175 vgp_self.n174 9.3005
R3617 vgp_self.n180 vgp_self.n179 9.3005
R3618 vgp_self.n182 vgp_self.n181 9.3005
R3619 vgp_self.n112 vgp_self 9.343
R3620 vgp_self vgp_self.n114 0.138
R3621 vgp_self.n117 vgp_self.n114 0.1805
R3622 vgp_self.n124 vgp_self.n117 0.3905
R3623 vgp_self.n121 vgp_self.n124 0.1805
R3624 vgp_self.n121 vgp_self 0.043
R3625 vgp_self vgp_self.n119 0.138
R3626 vgp_self.n131 vgp_self.n119 0.3905
R3627 vgp_self.n131 vgp_self 0.0955
R3628 vgp_self vgp_self.n128 0.0855
R3629 vgp_self.n126 vgp_self.n128 0.1805
R3630 vgp_self.n137 vgp_self.n126 0.3905
R3631 vgp_self.n137 vgp_self 0.1805
R3632 vgp_self vgp_self.n133 0.1805
R3633 vgp_self.n144 vgp_self.n133 0.3905
R3634 vgp_self.n141 vgp_self.n144 0.1805
R3635 vgp_self.n141 vgp_self 0.138
R3636 vgp_self vgp_self.n139 0.043
R3637 vgp_self.n151 vgp_self.n139 0.3905
R3638 vgp_self.n148 vgp_self.n151 0.1805
R3639 vgp_self.n148 vgp_self 0.043
R3640 vgp_self vgp_self.n146 0.138
R3641 vgp_self.n158 vgp_self.n146 0.3905
R3642 vgp_self.n158 vgp_self 0.138
R3643 vgp_self vgp_self.n155 0.043
R3644 vgp_self.n153 vgp_self.n155 0.1805
R3645 vgp_self.n253 vgp_self.n153 0.1955
R3646 vgp_self.n253 vgp_self.n165 0.1955
R3647 vgp_self.n165 vgp_self.n162 0.1805
R3648 vgp_self.n162 vgp_self 0.043
R3649 vgp_self vgp_self.n160 0.138
R3650 vgp_self.n160 vgp_self.n171 0.3905
R3651 vgp_self.n171 vgp_self 0.1805
R3652 vgp_self vgp_self.n167 0.1805
R3653 vgp_self.n219 vgp_self.n167 0.1955
R3654 vgp_self.n219 vgp_self.n178 0.1955
R3655 vgp_self.n178 vgp_self.n175 0.1805
R3656 vgp_self.n175 vgp_self 0.043
R3657 vgp_self vgp_self.n173 0.138
R3658 vgp_self.n185 vgp_self.n173 0.3905
R3659 vgp_self.n185 vgp_self 0.138
R3660 vgp_self vgp_self.n182 0.043
R3661 vgp_self.n180 vgp_self.n182 0.1805
R3662 vgp_self.n252 vgp_self.n180 0.1955
R3663 vgp_self.n252 vgp_self.n186 0.288681
R3664 vgp_self.n222 vgp_self.n221 9.3005
R3665 vgp_self.n224 vgp_self.n223 9.3005
R3666 vgp_self.n226 vgp_self.n225 9.3005
R3667 vgp_self.n228 vgp_self.n227 9.3005
R3668 vgp_self.n230 vgp_self.n229 9.3005
R3669 vgp_self.n232 vgp_self.n231 9.3005
R3670 vgp_self.n234 vgp_self.n233 9.3005
R3671 vgp_self.n236 vgp_self.n235 9.3005
R3672 vgp_self.n237 vgp_self.n238 9.3005
R3673 vgp_self.n240 vgp_self.n239 9.3005
R3674 vgp_self.n242 vgp_self.n241 9.3005
R3675 vgp_self.n251 vgp_self.n243 9.3005
R3676 vgp_self.n25 vgp_self.n220 0.533
R3677 vgp_self.n220 vgp_self.n222 0.1805
R3678 vgp_self.n222 vgp_self.n224 0.1805
R3679 vgp_self.n224 vgp_self.n226 0.1805
R3680 vgp_self.n226 vgp_self.n228 0.1805
R3681 vgp_self.n228 vgp_self.n230 0.1805
R3682 vgp_self.n230 vgp_self.n232 0.1805
R3683 vgp_self.n232 vgp_self.n234 0.1805
R3684 vgp_self.n234 vgp_self.n236 0.1805
R3685 vgp_self.n236 vgp_self 0.043
R3686 vgp_self vgp_self.n238 0.138
R3687 vgp_self.n238 vgp_self.n240 0.1805
R3688 vgp_self.n240 vgp_self.n242 0.1805
R3689 vgp_self.n242 vgp_self.n251 0.1805
R3690 vgp_self.n251 vgp_self.n252 0.2905
R3691 vgp_self.n249 vgp_self.n250 285.877
R3692 vgp_self.n249 vgp_self.n221 13.2471
R3693 vgp_self.n250 vgp_self.n248 285.877
R3694 vgp_self.n248 vgp_self.n225 13.2471
R3695 vgp_self.n250 vgp_self.n247 285.877
R3696 vgp_self.n247 vgp_self.n229 13.2471
R3697 vgp_self.n250 vgp_self.n246 285.877
R3698 vgp_self.n246 vgp_self.n233 13.2471
R3699 vgp_self.n250 vgp_self.n245 285.877
R3700 vgp_self.n245 vgp_self.n237 13.2471
R3701 vgp_self.n250 vgp_self.n244 285.877
R3702 vgp_self.n244 vgp_self.n241 13.2471
R3703 vgp_self.n250 vgp_self.n243 585
R3704 vgp_self.n220 vgp_self.n249 22.5471
R3705 vgp_self.n221 vgp_self.n223 27.1064
R3706 vgp_self.n223 vgp_self.n248 13.2471
R3707 vgp_self.n225 vgp_self.n227 27.1064
R3708 vgp_self.n227 vgp_self.n247 13.2471
R3709 vgp_self.n229 vgp_self.n231 27.1064
R3710 vgp_self.n231 vgp_self.n246 13.2471
R3711 vgp_self.n233 vgp_self.n235 27.1064
R3712 vgp_self.n235 vgp_self.n245 13.2471
R3713 vgp_self.n237 vgp_self.n239 27.1064
R3714 vgp_self.n239 vgp_self.n244 13.2471
R3715 vgp_self.n241 vgp_self.n243 27.1064
R3716 vgp_self.n250 vgp_self.t16 9.8505
R3717 vgp_self.n250 vgp_self.t18 9.8505
R3718 vgp_self.n189 vgp_self.n188 9.3005
R3719 vgp_self.n191 vgp_self.n190 9.3005
R3720 vgp_self.n193 vgp_self.n192 9.3005
R3721 vgp_self.n195 vgp_self.n194 9.3005
R3722 vgp_self.n197 vgp_self.n196 9.3005
R3723 vgp_self.n199 vgp_self.n198 9.3005
R3724 vgp_self.n201 vgp_self.n200 9.3005
R3725 vgp_self.n202 vgp_self.n203 9.3005
R3726 vgp_self.n205 vgp_self.n204 9.3005
R3727 vgp_self.n207 vgp_self.n206 9.3005
R3728 vgp_self.n209 vgp_self.n208 9.3005
R3729 vgp_self.n218 vgp_self.n210 9.3005
R3730 vgp_self.n48 vgp_self.n187 0.533
R3731 vgp_self.n187 vgp_self.n189 0.1805
R3732 vgp_self.n189 vgp_self.n191 0.1805
R3733 vgp_self.n191 vgp_self.n193 0.1805
R3734 vgp_self.n193 vgp_self.n195 0.1805
R3735 vgp_self.n195 vgp_self.n197 0.1805
R3736 vgp_self.n197 vgp_self.n199 0.1805
R3737 vgp_self.n199 vgp_self.n201 0.1805
R3738 vgp_self.n201 vgp_self 0.043
R3739 vgp_self vgp_self.n203 0.138
R3740 vgp_self.n203 vgp_self.n205 0.1805
R3741 vgp_self.n205 vgp_self.n207 0.1805
R3742 vgp_self.n207 vgp_self.n209 0.1805
R3743 vgp_self.n209 vgp_self.n218 0.1805
R3744 vgp_self.n218 vgp_self.n219 0.2905
R3745 vgp_self.n216 vgp_self.n217 285.877
R3746 vgp_self.n216 vgp_self.n188 13.2471
R3747 vgp_self.n217 vgp_self.n215 285.877
R3748 vgp_self.n215 vgp_self.n192 13.2471
R3749 vgp_self.n217 vgp_self.n214 285.877
R3750 vgp_self.n214 vgp_self.n196 13.2471
R3751 vgp_self.n217 vgp_self.n213 285.877
R3752 vgp_self.n213 vgp_self.n200 13.2471
R3753 vgp_self.n217 vgp_self.n212 285.877
R3754 vgp_self.n212 vgp_self.n204 13.2471
R3755 vgp_self.n217 vgp_self.n211 285.877
R3756 vgp_self.n211 vgp_self.n208 13.2471
R3757 vgp_self.n217 vgp_self.n210 585
R3758 vgp_self.n187 vgp_self.n216 22.5471
R3759 vgp_self.n188 vgp_self.n190 27.1064
R3760 vgp_self.n190 vgp_self.n215 13.2471
R3761 vgp_self.n192 vgp_self.n194 27.1064
R3762 vgp_self.n194 vgp_self.n214 13.2471
R3763 vgp_self.n196 vgp_self.n198 27.1064
R3764 vgp_self.n198 vgp_self.n213 13.2471
R3765 vgp_self.n200 vgp_self.n202 27.1064
R3766 vgp_self.n202 vgp_self.n212 13.2471
R3767 vgp_self.n204 vgp_self.n206 27.1064
R3768 vgp_self.n206 vgp_self.n211 13.2471
R3769 vgp_self.n208 vgp_self.n210 27.1064
R3770 vgp_self.n217 vgp_self.t12 9.8505
R3771 vgp_self.n217 vgp_self.t14 9.8505
R3772 vgp_self.n186 vgp_self 0.0453581
R3773 vgp_self.n186 vgp_self.t17 181.078
R3774 vgp_self.n181 vgp_self.n183 11.3247
R3775 vgp_self.n183 vgp_self.n185 23.0638
R3776 vgp_self.n181 vgp_self.n179 27.1064
R3777 vgp_self.n183 vgp_self.n184 77.1778
R3778 vgp_self.n184 vgp_self.n179 184.74
R3779 vgp_self.n184 vgp_self.t15 120.501
R3780 vgp_self.n174 vgp_self.n176 11.3247
R3781 vgp_self.n178 vgp_self.n176 23.0638
R3782 vgp_self.n174 vgp_self.n172 27.1064
R3783 vgp_self.n176 vgp_self.n177 77.1778
R3784 vgp_self.n177 vgp_self.n172 184.74
R3785 vgp_self.n177 vgp_self.t13 120.501
R3786 vgp_self.n168 vgp_self.n169 11.3247
R3787 vgp_self.n171 vgp_self.n169 23.0638
R3788 vgp_self.n166 vgp_self.n168 27.1064
R3789 vgp_self.n169 vgp_self.n170 77.1778
R3790 vgp_self.n170 vgp_self.n166 184.74
R3791 vgp_self.n170 vgp_self.t11 120.501
R3792 vgp_self.n161 vgp_self.n163 11.3247
R3793 vgp_self.n165 vgp_self.n163 23.0638
R3794 vgp_self.n161 vgp_self.n159 27.1064
R3795 vgp_self.n163 vgp_self.n164 77.1778
R3796 vgp_self.n164 vgp_self.n159 184.74
R3797 vgp_self.n164 vgp_self.t9 120.501
R3798 vgp_self.n154 vgp_self.n156 11.3247
R3799 vgp_self.n156 vgp_self.n158 23.0638
R3800 vgp_self.n154 vgp_self.n152 27.1064
R3801 vgp_self.n156 vgp_self.n157 77.1778
R3802 vgp_self.n157 vgp_self.n152 184.74
R3803 vgp_self.n157 vgp_self.t7 120.501
R3804 vgp_self.n147 vgp_self.n149 11.3247
R3805 vgp_self.n151 vgp_self.n149 23.0638
R3806 vgp_self.n145 vgp_self.n147 27.1064
R3807 vgp_self.n149 vgp_self.n150 77.1778
R3808 vgp_self.n150 vgp_self.n145 184.74
R3809 vgp_self.n150 vgp_self.t20 120.501
R3810 vgp_self.n140 vgp_self.n142 11.3247
R3811 vgp_self.n144 vgp_self.n142 23.0638
R3812 vgp_self.n138 vgp_self.n140 27.1064
R3813 vgp_self.n142 vgp_self.n143 77.1778
R3814 vgp_self.n143 vgp_self.n138 184.74
R3815 vgp_self.n143 vgp_self.t21 120.501
R3816 vgp_self.n134 vgp_self.n135 11.3247
R3817 vgp_self.n135 vgp_self.n137 23.0638
R3818 vgp_self.n132 vgp_self.n134 27.1064
R3819 vgp_self.n135 vgp_self.n136 77.1778
R3820 vgp_self.n136 vgp_self.n132 184.74
R3821 vgp_self.n136 vgp_self.t22 120.501
R3822 vgp_self.n127 vgp_self.n129 11.3247
R3823 vgp_self.n129 vgp_self.n131 23.0638
R3824 vgp_self.n127 vgp_self.n125 27.1064
R3825 vgp_self.n129 vgp_self.n130 77.1778
R3826 vgp_self.n130 vgp_self.n125 184.74
R3827 vgp_self.n130 vgp_self.t23 120.501
R3828 vgp_self.n120 vgp_self.n122 11.3247
R3829 vgp_self.n124 vgp_self.n122 23.0638
R3830 vgp_self.n118 vgp_self.n120 27.1064
R3831 vgp_self.n122 vgp_self.n123 77.1778
R3832 vgp_self.n123 vgp_self.n118 184.74
R3833 vgp_self.n123 vgp_self.t24 120.501
R3834 vgp_self.n113 vgp_self.n115 11.3247
R3835 vgp_self.n113 vgp_self.n112 27.1064
R3836 vgp_self.n115 vgp_self.n117 23.0638
R3837 vgp_self.n112 vgp_self.n116 184.74
R3838 vgp_self.n115 vgp_self.n116 77.1778
R3839 vgp_self.n116 vgp_self.t25 120.501
R3840 vgp_self.n109 vgp_self.n110 285.877
R3841 vgp_self.n109 vgp_self.n81 13.2471
R3842 vgp_self.n110 vgp_self.n108 285.877
R3843 vgp_self.n108 vgp_self.n85 13.2471
R3844 vgp_self.n110 vgp_self.n107 285.877
R3845 vgp_self.n107 vgp_self.n89 13.2471
R3846 vgp_self.n110 vgp_self.n106 285.877
R3847 vgp_self.n106 vgp_self.n93 13.2471
R3848 vgp_self.n110 vgp_self.n105 285.877
R3849 vgp_self.n105 vgp_self.n97 13.2471
R3850 vgp_self.n110 vgp_self.n104 285.877
R3851 vgp_self.n104 vgp_self.n101 13.2471
R3852 vgp_self.n110 vgp_self.n103 585
R3853 vgp_self.n80 vgp_self.n109 22.5471
R3854 vgp_self.n81 vgp_self.n83 27.1064
R3855 vgp_self.n83 vgp_self.n108 13.2471
R3856 vgp_self.n85 vgp_self.n87 27.1064
R3857 vgp_self.n87 vgp_self.n107 13.2471
R3858 vgp_self.n89 vgp_self.n91 27.1064
R3859 vgp_self.n91 vgp_self.n106 13.2471
R3860 vgp_self.n93 vgp_self.n95 27.1064
R3861 vgp_self.n95 vgp_self.n105 13.2471
R3862 vgp_self.n97 vgp_self.n99 27.1064
R3863 vgp_self.n99 vgp_self.n104 13.2471
R3864 vgp_self.n101 vgp_self.n103 27.1064
R3865 vgp_self.n110 vgp_self.t8 9.8505
R3866 vgp_self.n110 vgp_self.t10 9.8505
R3867 vgp_self.n62 vgp_self.n61 9.3005
R3868 vgp_self.n68 vgp_self.n67 9.3005
R3869 vgp_self.n63 vgp_self.n62 0.0611776
R3870 vgp_self.n68 vgp_self.n63 0.0611758
R3871 vgp_self.n50 vgp_self.n68 0.144824
R3872 vgp_self.n71 vgp_self.n70 9.3005
R3873 vgp_self.n79 vgp_self.n72 9.3005
R3874 vgp_self vgp_self.n69 0.0255
R3875 vgp_self.n71 vgp_self.n69 0.1805
R3876 vgp_self.n79 vgp_self.n71 0.1805
R3877 vgp_self.n62 vgp_self.n79 0.144824
R3878 vgp_self.n78 vgp_self.n77 86.1871
R3879 vgp_self.n70 vgp_self.n77 12.6288
R3880 vgp_self.n78 vgp_self.n76 86.1871
R3881 vgp_self.n61 vgp_self.n76 12.6288
R3882 vgp_self.n78 vgp_self.n75 86.1871
R3883 vgp_self.n49 vgp_self.n75 12.6288
R3884 vgp_self.n78 vgp_self.n74 86.1871
R3885 vgp_self.n53 vgp_self.n74 12.6288
R3886 vgp_self.n73 vgp_self.n78 86.1871
R3887 vgp_self.n57 vgp_self.n73 12.6288
R3888 vgp_self.n78 vgp_self.n59 185
R3889 vgp_self.n69 vgp_self.n77 21.9288
R3890 vgp_self.n70 vgp_self.n72 27.1064
R3891 vgp_self.n72 vgp_self.n76 12.6288
R3892 vgp_self.n61 vgp_self.n67 27.1064
R3893 vgp_self.n67 vgp_self.n75 12.6288
R3894 vgp_self.n49 vgp_self.n51 27.1064
R3895 vgp_self.n51 vgp_self.n74 12.6288
R3896 vgp_self.n53 vgp_self.n55 27.1064
R3897 vgp_self.n55 vgp_self.n73 12.6288
R3898 vgp_self.n57 vgp_self.n59 27.1064
R3899 vgp_self.n78 vgp_self.t0 7.5005
R3900 vgp_self.n78 vgp_self.t1 7.5005
R3901 vgp_self.n63 vgp_self.n66 3.9495
R3902 vgp_self.n27 vgp_self.n66 0.410967
R3903 vgp_self vgp_self.n64 0.0361338
R3904 vgp_self.n66 vgp_self.n64 9.2988
R3905 vgp_self.n64 vgp_self.n65 97.1447
R3906 vgp_self.n65 vgp_self.t19 30.0005
R3907 vgp_self.n65 vgp_self.t6 30.0005
R3908 vdinv.t0 vdinv.n59 653.4
R3909 vdinv.n0 vdinv.n1 4.5005
R3910 vdinv.n59 vdinv.n0 0.0175455
R3911 vdinv vdinv.n59 0.0118636
R3912 vdinv.n58 vdinv.n0 5.93065
R3913 vdinv.n57 vdinv.n58 0.578909
R3914 vdinv.n47 vdinv.n46 4.5005
R3915 vdinv.n55 vdinv.n56 4.5005
R3916 vdinv.n56 vdinv.n45 4.60861
R3917 vdinv.n47 vdinv.n56 0.108608
R3918 vdinv.n57 vdinv.n47 1.98051
R3919 vdinv.n50 vdinv.n49 9.3005
R3920 vdinv.n52 vdinv.n51 9.3005
R3921 vdinv.n45 vdinv 0.0157027
R3922 vdinv vdinv.n50 0.0292162
R3923 vdinv.n55 vdinv.n50 0.0646892
R3924 vdinv.n52 vdinv.n55 0.0579324
R3925 vdinv.n46 vdinv.n52 0.0511757
R3926 vdinv.n45 vdinv.n48 6.70832
R3927 vdinv.n48 vdinv.n54 27.0284
R3928 vdinv.n54 vdinv.n53 32.5886
R3929 vdinv.n48 vdinv.n49 23.5032
R3930 vdinv.n49 vdinv.n51 27.1064
R3931 vdinv.n51 vdinv.n53 22.4148
R3932 vdinv.n54 vdinv.t3 7.5005
R3933 vdinv.n54 vdinv.t4 7.5005
R3934 vdinv.n46 vdinv.n53 8.05482
R3935 vdinv.n1 vdinv.n57 0.637242
R3936 vdinv.n16 vdinv.n15 4.5005
R3937 vdinv.n43 vdinv.n44 4.5005
R3938 vdinv.n14 vdinv.n44 4.60861
R3939 vdinv.n16 vdinv.n44 0.108608
R3940 vdinv.n1 vdinv.n16 2.53809
R3941 vdinv.n18 vdinv.n17 9.3005
R3942 vdinv.n20 vdinv.n19 9.3005
R3943 vdinv.n22 vdinv.n21 9.3005
R3944 vdinv.n14 vdinv.n18 0.0782027
R3945 vdinv.n20 vdinv.n14 0.0444189
R3946 vdinv.n43 vdinv.n20 0.0646892
R3947 vdinv.n22 vdinv.n43 0.0579324
R3948 vdinv.n15 vdinv.n22 0.0511757
R3949 vdinv.n26 vdinv.n25 9.3005
R3950 vdinv.n28 vdinv.n27 9.3005
R3951 vdinv.n29 vdinv.n34 9.3005
R3952 vdinv.n26 vdinv.n24 0.196152
R3953 vdinv.n28 vdinv.n26 0.196152
R3954 vdinv.n34 vdinv.n28 0.196152
R3955 vdinv.n34 vdinv 0.149957
R3956 vdinv vdinv.n18 0.0364136
R3957 vdinv.n24 vdinv.n35 1.71751
R3958 vdinv.n37 vdinv.n36 9.3005
R3959 vdinv.n38 vdinv.n41 9.3005
R3960 vdinv.n35 vdinv 0.144667
R3961 vdinv vdinv.n41 0.0355
R3962 vdinv.n41 vdinv.n37 0.1805
R3963 vdinv.n37 vdinv.n42 0.508957
R3964 vdinv.n42 vdinv 0.0572957
R3965 vdinv.n42 vdinv.t6 84.6534
R3966 vdinv.n39 vdinv.n38 11.3247
R3967 vdinv.n35 vdinv.n39 23.0638
R3968 vdinv.n38 vdinv.n36 27.1064
R3969 vdinv.n39 vdinv.n40 77.1778
R3970 vdinv.n40 vdinv.n36 184.74
R3971 vdinv.n40 vdinv.t7 24.1005
R3972 vdinv.n30 vdinv.n24 21.9288
R3973 vdinv.n33 vdinv.n30 86.1871
R3974 vdinv.n31 vdinv.n27 12.6288
R3975 vdinv.n33 vdinv.n31 86.1871
R3976 vdinv.n32 vdinv.n17 12.6288
R3977 vdinv.n33 vdinv.n32 86.1871
R3978 vdinv.n23 vdinv.n33 32.5886
R3979 vdinv.n25 vdinv.n30 12.6288
R3980 vdinv.n25 vdinv.n27 27.1064
R3981 vdinv.n29 vdinv.n31 12.6288
R3982 vdinv.n17 vdinv.n29 27.1064
R3983 vdinv.n19 vdinv.n32 12.6288
R3984 vdinv.n19 vdinv.n21 27.1064
R3985 vdinv.n21 vdinv.n23 22.4148
R3986 vdinv.n33 vdinv.t5 4.5005
R3987 vdinv.n15 vdinv.n23 8.05482
R3988 vdinv.n4 vdinv.n3 4.5005
R3989 vdinv.n12 vdinv.n13 4.5005
R3990 vdinv.n2 vdinv.n13 4.60861
R3991 vdinv.n4 vdinv.n13 0.108608
R3992 vdinv.n58 vdinv.n4 2.64017
R3993 vdinv.n7 vdinv.n6 9.3005
R3994 vdinv.n9 vdinv.n8 9.3005
R3995 vdinv vdinv.n2 0.0494865
R3996 vdinv.n7 vdinv.n2 0.0444189
R3997 vdinv.n12 vdinv.n7 0.0646892
R3998 vdinv.n9 vdinv.n12 0.0579324
R3999 vdinv.n3 vdinv.n9 0.0511757
R4000 vdinv.n5 vdinv 6.65933
R4001 vdinv.n11 vdinv.n5 27.0284
R4002 vdinv.n10 vdinv.n11 32.5886
R4003 vdinv.n6 vdinv.n5 23.5032
R4004 vdinv.n6 vdinv.n8 27.1064
R4005 vdinv.n8 vdinv.n10 22.4148
R4006 vdinv.n11 vdinv.t1 7.5005
R4007 vdinv.n11 vdinv.t2 7.5005
R4008 vdinv.n3 vdinv.n10 8.05482
R4009 vp1 vp1.t0 653.821
R4010 vp1 vp1.t1 653.4
R4011 vp2.t0 vp2.n0 653.831
R4012 vp2 vp2.n0 0.0371379
R4013 vp2.n0 vp2.t1 653.4
R4014 vp3 vp3.t0 653.438
R4015 vp3 vp3.t1 653.793
R4016 vp4.t0 vp4 653.438
R4017 vp4 vp4.t1 653.793
C0 vp4 VR 0.07758f
C1 vgp_self vdi 3.9942f
C2 vgp_self VDD 12.125f
C3 vdi VDD 3.51758f
C4 vgp_self VR 2.60179f
C5 vdinv vgp_self 0.14802f
C6 vp1 VDD 0.13978f
C7 vdi VR 3.0336f
C8 VDD VR 4.28734f
C9 vp2 vp4 0.0227f
C10 vdinv vdi 0.08835f
C11 vdinv VDD 0.6833f
C12 vp1 VR 0.09861f
C13 vp1 vdinv 0.0208f
C14 vdinv VR 2.58678f
C15 vp3 VDD 0.14839f
C16 vp3 vp1 0.0227f
C17 vp3 VR 0.07778f
C18 vp2 VDD 0.14271f
C19 vp2 VR 0.07769f
C20 vp2 vdinv 0.02834f
C21 vp4 VDD 0.17668f
C22 VR VSS 11.12094f
C23 VDD VSS 24.25724f
C24 vdi VSS 4.25476f
C25 vgp_self VSS 2.68792f
C26 vdinv VSS 4.46957f
C27 vp1 VSS 0.20217f
C28 vp2 VSS 0.01314f
C29 vp3 VSS 0.18512f
C30 vp4 VSS 0.1823f
C31 vp4.t0 VSS 0.05419f
C32 vp4.t1 VSS 0.05423f
C33 vp3.t0 VSS 0.04935f
C34 vp3.t1 VSS 0.04939f
C35 vp2.t0 VSS 0.05382f
C36 vp2.t1 VSS 0.05376f
C37 vp2.n0 VSS 0.16124f
C38 vp1.t0 VSS 0.05532f
C39 vp1.t1 VSS 0.05526f
C40 vdinv.t0 VSS 0.02153f
C41 vdinv.n0 VSS 0.11149f
C42 vdinv.n1 VSS 0.18354f
C43 vdinv.n3 VSS 0.09019f
C44 vdinv.n4 VSS 0.1616f
C45 vdinv.n6 VSS 0.01114f
C46 vdinv.n8 VSS 0.01097f
C47 vdinv.n11 VSS 0.15643f
C48 vdinv.t1 VSS 0.07654f
C49 vdinv.t2 VSS 0.07654f
C50 vdinv.n12 VSS 0.01019f
C51 vdinv.n13 VSS 0.04246f
C52 vdinv.n14 VSS 0.01078f
C53 vdinv.n15 VSS 0.09019f
C54 vdinv.n16 VSS 0.15577f
C55 vdinv.n21 VSS 0.01097f
C56 vdinv.n24 VSS 0.081f
C57 vdinv.n26 VSS 0.01267f
C58 vdinv.n28 VSS 0.01267f
C59 vdinv.n33 VSS 0.13908f
C60 vdinv.t5 VSS 0.04592f
C61 vdinv.n34 VSS 0.01118f
C62 vdinv.n35 VSS 0.07976f
C63 vdinv.n36 VSS 0.01358f
C64 vdinv.n37 VSS 0.02907f
C65 vdinv.t7 VSS 0.08419f
C66 vdinv.n40 VSS 0.1102f
C67 vdinv.n42 VSS 0.06433f
C68 vdinv.t6 VSS 0.16436f
C69 vdinv.n43 VSS 0.01019f
C70 vdinv.n44 VSS 0.04246f
C71 vdinv.n45 VSS 0.10909f
C72 vdinv.n46 VSS 0.09019f
C73 vdinv.n47 VSS 0.12348f
C74 vdinv.n49 VSS 0.01114f
C75 vdinv.n51 VSS 0.01097f
C76 vdinv.n54 VSS 0.15643f
C77 vdinv.t3 VSS 0.07654f
C78 vdinv.t4 VSS 0.07654f
C79 vdinv.n55 VSS 0.01019f
C80 vdinv.n56 VSS 0.04246f
C81 vdinv.n57 VSS 0.17639f
C82 vdinv.n58 VSS 0.20214f
C83 vdinv.n59 VSS 0.01192f
C84 vgp_self.t5 VSS 0.08956f
C85 vgp_self.n0 VSS 0.17911f
C86 vgp_self.n1 VSS 0.01051f
C87 vgp_self.n2 VSS 0.01096f
C88 vgp_self.n4 VSS 0.01096f
C89 vgp_self.n5 VSS 0.01096f
C90 vgp_self.n7 VSS 0.01096f
C91 vgp_self.n8 VSS 0.01096f
C92 vgp_self.n10 VSS 0.01096f
C93 vgp_self.n11 VSS 0.01096f
C94 vgp_self.n13 VSS 0.01096f
C95 vgp_self.n14 VSS 0.01096f
C96 vgp_self.n16 VSS 0.0159f
C97 vgp_self.n17 VSS 0.01656f
C98 vgp_self.n18 VSS 0.0233f
C99 vgp_self.n19 VSS 0.0233f
C100 vgp_self.n20 VSS 0.01656f
C101 vgp_self.n21 VSS 0.01612f
C102 vgp_self.n22 VSS 0.01612f
C103 vgp_self.n23 VSS 0.01612f
C104 vgp_self.n24 VSS 0.01612f
C105 vgp_self.n25 VSS 0.12359f
C106 vgp_self.n26 VSS 0.03971f
C107 vgp_self.n27 VSS 0.36279f
C108 vgp_self.n28 VSS 0.02519f
C109 vgp_self.n29 VSS 0.01096f
C110 vgp_self.n30 VSS 0.0233f
C111 vgp_self.n31 VSS 0.01096f
C112 vgp_self.n32 VSS 0.0233f
C113 vgp_self.n33 VSS 0.01545f
C114 vgp_self.n34 VSS 0.01096f
C115 vgp_self.n35 VSS 0.01612f
C116 vgp_self.n36 VSS 0.01096f
C117 vgp_self.n37 VSS 0.01096f
C118 vgp_self.n38 VSS 0.01656f
C119 vgp_self.n39 VSS 0.01096f
C120 vgp_self.n40 VSS 0.01612f
C121 vgp_self.n41 VSS 0.01096f
C122 vgp_self.n42 VSS 0.01612f
C123 vgp_self.n43 VSS 0.01096f
C124 vgp_self.n44 VSS 0.01612f
C125 vgp_self.n45 VSS 0.01096f
C126 vgp_self.n46 VSS 0.01612f
C127 vgp_self.n47 VSS 0.01051f
C128 vgp_self.n48 VSS 0.18516f
C129 vgp_self.n49 VSS 0.01096f
C130 vgp_self.n50 VSS 0.01656f
C131 vgp_self.n51 VSS 0.01096f
C132 vgp_self.n52 VSS 0.01612f
C133 vgp_self.n53 VSS 0.01096f
C134 vgp_self.n54 VSS 0.01612f
C135 vgp_self.n55 VSS 0.01096f
C136 vgp_self.n56 VSS 0.01612f
C137 vgp_self.n57 VSS 0.01096f
C138 vgp_self.n58 VSS 0.01612f
C139 vgp_self.n59 VSS 0.01051f
C140 vgp_self.n60 VSS 0.03504f
C141 vgp_self.n61 VSS 0.01096f
C142 vgp_self.n62 VSS 0.0233f
C143 vgp_self.n63 VSS 0.02519f
C144 vgp_self.n64 VSS 0.12976f
C145 vgp_self.n65 VSS 0.04579f
C146 vgp_self.t19 VSS 0.02239f
C147 vgp_self.t6 VSS 0.02239f
C148 vgp_self.n66 VSS 0.54091f
C149 vgp_self.n67 VSS 0.01096f
C150 vgp_self.n68 VSS 0.0233f
C151 vgp_self.n69 VSS 0.01523f
C152 vgp_self.n70 VSS 0.01096f
C153 vgp_self.n71 VSS 0.01612f
C154 vgp_self.n72 VSS 0.01096f
C155 vgp_self.n78 VSS 0.17911f
C156 vgp_self.t0 VSS 0.08956f
C157 vgp_self.t1 VSS 0.08956f
C158 vgp_self.n79 VSS 0.01656f
C159 vgp_self.n80 VSS 0.03808f
C160 vgp_self.n81 VSS 0.01096f
C161 vgp_self.n82 VSS 0.01612f
C162 vgp_self.n83 VSS 0.01096f
C163 vgp_self.n84 VSS 0.01612f
C164 vgp_self.n85 VSS 0.01096f
C165 vgp_self.n86 VSS 0.01612f
C166 vgp_self.n87 VSS 0.01096f
C167 vgp_self.n88 VSS 0.01612f
C168 vgp_self.n89 VSS 0.01096f
C169 vgp_self.n90 VSS 0.01612f
C170 vgp_self.n91 VSS 0.01096f
C171 vgp_self.n92 VSS 0.01612f
C172 vgp_self.n93 VSS 0.01096f
C173 vgp_self.n94 VSS 0.01422f
C174 vgp_self.n95 VSS 0.01096f
C175 vgp_self.n97 VSS 0.01096f
C176 vgp_self.n98 VSS 0.01612f
C177 vgp_self.n99 VSS 0.01096f
C178 vgp_self.n100 VSS 0.01612f
C179 vgp_self.n101 VSS 0.01096f
C180 vgp_self.n102 VSS 0.01612f
C181 vgp_self.n103 VSS 0.01051f
C182 vgp_self.n110 VSS 0.22389f
C183 vgp_self.t8 VSS 0.11195f
C184 vgp_self.t10 VSS 0.11195f
C185 vgp_self.n111 VSS 0.02105f
C186 vgp_self.n112 VSS 0.01593f
C187 vgp_self.n113 VSS 0.01096f
C188 vgp_self.n114 VSS 0.01422f
C189 vgp_self.t25 VSS 0.63586f
C190 vgp_self.n116 VSS 0.30806f
C191 vgp_self.n117 VSS 0.03501f
C192 vgp_self.n118 VSS 0.01589f
C193 vgp_self.n119 VSS 0.02362f
C194 vgp_self.n120 VSS 0.01096f
C195 vgp_self.t24 VSS 0.63586f
C196 vgp_self.n123 VSS 0.30806f
C197 vgp_self.n124 VSS 0.03501f
C198 vgp_self.n125 VSS 0.01589f
C199 vgp_self.n126 VSS 0.02552f
C200 vgp_self.n127 VSS 0.01096f
C201 vgp_self.n128 VSS 0.01187f
C202 vgp_self.t23 VSS 0.63586f
C203 vgp_self.n130 VSS 0.30806f
C204 vgp_self.n131 VSS 0.0312f
C205 vgp_self.n132 VSS 0.01589f
C206 vgp_self.n133 VSS 0.02552f
C207 vgp_self.n134 VSS 0.01096f
C208 vgp_self.t22 VSS 0.63586f
C209 vgp_self.n136 VSS 0.30806f
C210 vgp_self.n137 VSS 0.03501f
C211 vgp_self.n138 VSS 0.01589f
C212 vgp_self.n139 VSS 0.01937f
C213 vgp_self.n140 VSS 0.01096f
C214 vgp_self.n141 VSS 0.01422f
C215 vgp_self.t21 VSS 0.63586f
C216 vgp_self.n143 VSS 0.30806f
C217 vgp_self.n144 VSS 0.03501f
C218 vgp_self.n145 VSS 0.01589f
C219 vgp_self.n146 VSS 0.02362f
C220 vgp_self.n147 VSS 0.01096f
C221 vgp_self.t20 VSS 0.63586f
C222 vgp_self.n150 VSS 0.30806f
C223 vgp_self.n151 VSS 0.03501f
C224 vgp_self.n152 VSS 0.01589f
C225 vgp_self.n153 VSS 0.01679f
C226 vgp_self.n154 VSS 0.01096f
C227 vgp_self.t7 VSS 0.63586f
C228 vgp_self.n157 VSS 0.30806f
C229 vgp_self.n158 VSS 0.0331f
C230 vgp_self.n159 VSS 0.01589f
C231 vgp_self.n160 VSS 0.02362f
C232 vgp_self.n161 VSS 0.01096f
C233 vgp_self.t9 VSS 0.63586f
C234 vgp_self.n164 VSS 0.30806f
C235 vgp_self.n165 VSS 0.02627f
C236 vgp_self.n166 VSS 0.01589f
C237 vgp_self.n167 VSS 0.01679f
C238 vgp_self.n168 VSS 0.01096f
C239 vgp_self.t11 VSS 0.63586f
C240 vgp_self.n170 VSS 0.30806f
C241 vgp_self.n171 VSS 0.03501f
C242 vgp_self.n172 VSS 0.01589f
C243 vgp_self.n173 VSS 0.02362f
C244 vgp_self.n174 VSS 0.01096f
C245 vgp_self.t13 VSS 0.63586f
C246 vgp_self.n177 VSS 0.30806f
C247 vgp_self.n178 VSS 0.02627f
C248 vgp_self.n179 VSS 0.01589f
C249 vgp_self.n180 VSS 0.01679f
C250 vgp_self.n181 VSS 0.01096f
C251 vgp_self.t15 VSS 0.63586f
C252 vgp_self.n184 VSS 0.30806f
C253 vgp_self.n185 VSS 0.0331f
C254 vgp_self.n186 VSS 0.23419f
C255 vgp_self.t17 VSS 0.73966f
C256 vgp_self.n187 VSS 0.03808f
C257 vgp_self.n188 VSS 0.01096f
C258 vgp_self.n189 VSS 0.01612f
C259 vgp_self.n190 VSS 0.01096f
C260 vgp_self.n191 VSS 0.01612f
C261 vgp_self.n192 VSS 0.01096f
C262 vgp_self.n193 VSS 0.01612f
C263 vgp_self.n194 VSS 0.01096f
C264 vgp_self.n195 VSS 0.01612f
C265 vgp_self.n196 VSS 0.01096f
C266 vgp_self.n197 VSS 0.01612f
C267 vgp_self.n198 VSS 0.01096f
C268 vgp_self.n199 VSS 0.01612f
C269 vgp_self.n200 VSS 0.01096f
C270 vgp_self.n202 VSS 0.01096f
C271 vgp_self.n203 VSS 0.01422f
C272 vgp_self.n204 VSS 0.01096f
C273 vgp_self.n205 VSS 0.01612f
C274 vgp_self.n206 VSS 0.01096f
C275 vgp_self.n207 VSS 0.01612f
C276 vgp_self.n208 VSS 0.01096f
C277 vgp_self.n209 VSS 0.01612f
C278 vgp_self.n210 VSS 0.01051f
C279 vgp_self.n217 VSS 0.22389f
C280 vgp_self.t12 VSS 0.11195f
C281 vgp_self.t14 VSS 0.11195f
C282 vgp_self.n218 VSS 0.02105f
C283 vgp_self.n219 VSS 0.03045f
C284 vgp_self.n220 VSS 0.03808f
C285 vgp_self.n221 VSS 0.01096f
C286 vgp_self.n222 VSS 0.01612f
C287 vgp_self.n223 VSS 0.01096f
C288 vgp_self.n224 VSS 0.01612f
C289 vgp_self.n225 VSS 0.01096f
C290 vgp_self.n226 VSS 0.01612f
C291 vgp_self.n227 VSS 0.01096f
C292 vgp_self.n228 VSS 0.01612f
C293 vgp_self.n229 VSS 0.01096f
C294 vgp_self.n230 VSS 0.01612f
C295 vgp_self.n231 VSS 0.01096f
C296 vgp_self.n232 VSS 0.01612f
C297 vgp_self.n233 VSS 0.01096f
C298 vgp_self.n234 VSS 0.01612f
C299 vgp_self.n235 VSS 0.01096f
C300 vgp_self.n237 VSS 0.01096f
C301 vgp_self.n238 VSS 0.01422f
C302 vgp_self.n239 VSS 0.01096f
C303 vgp_self.n240 VSS 0.01612f
C304 vgp_self.n241 VSS 0.01096f
C305 vgp_self.n242 VSS 0.01612f
C306 vgp_self.n243 VSS 0.01051f
C307 vgp_self.n250 VSS 0.22389f
C308 vgp_self.t16 VSS 0.11195f
C309 vgp_self.t18 VSS 0.11195f
C310 vgp_self.n251 VSS 0.02105f
C311 vgp_self.n252 VSS 0.03886f
C312 vgp_self.n253 VSS 0.03045f
C313 vgp_self.n254 VSS 0.12359f
C314 vgp_self.n255 VSS 0.03504f
C315 vgp_self.n261 VSS 0.17911f
C316 vgp_self.t2 VSS 0.08956f
C317 vgp_self.t3 VSS 0.08956f
C318 vgp_self.n262 VSS 0.01656f
C319 vgp_self.n263 VSS 0.04109f
C320 vgp_self.t4 VSS 0.08956f
C321 vdi.t10 VSS 0.04272f
C322 vdi.n0 VSS 0.01722f
C323 vdi.n1 VSS 0.01723f
C324 vdi.n2 VSS 0.01996f
C325 vdi.n3 VSS 0.16874f
C326 vdi.n4 VSS 0.01788f
C327 vdi.n5 VSS 0.10292f
C328 vdi.n6 VSS 0.01065f
C329 vdi.n7 VSS 0.02425f
C330 vdi.n8 VSS 0.02235f
C331 vdi.n9 VSS 0.05152f
C332 vdi.n10 VSS 0.0165f
C333 vdi.n11 VSS 0.01065f
C334 vdi.n12 VSS 0.04808f
C335 vdi.n13 VSS 0.01893f
C336 vdi.n14 VSS 0.02425f
C337 vdi.n15 VSS 0.01065f
C338 vdi.n16 VSS 0.02425f
C339 vdi.n17 VSS 0.01065f
C340 vdi.n18 VSS 0.02425f
C341 vdi.n19 VSS 0.01065f
C342 vdi.n20 VSS 0.02425f
C343 vdi.n21 VSS 0.01065f
C344 vdi.n22 VSS 0.02425f
C345 vdi.n24 VSS 0.02425f
C346 vdi.n25 VSS 0.01065f
C347 vdi.n26 VSS 0.02425f
C348 vdi.n27 VSS 0.01065f
C349 vdi.n28 VSS 0.02425f
C350 vdi.n29 VSS 0.01065f
C351 vdi.n30 VSS 0.02425f
C352 vdi.n31 VSS 0.01893f
C353 vdi.n32 VSS 0.01131f
C354 vdi.n34 VSS 0.01131f
C355 vdi.n35 VSS 0.01131f
C356 vdi.n37 VSS 0.01131f
C357 vdi.n39 VSS 0.01131f
C358 vdi.n41 VSS 0.01131f
C359 vdi.n43 VSS 0.01131f
C360 vdi.n45 VSS 0.01131f
C361 vdi.n47 VSS 0.01131f
C362 vdi.n49 VSS 0.01131f
C363 vdi.n50 VSS 0.01131f
C364 vdi.n52 VSS 0.01086f
C365 vdi.n59 VSS 0.23108f
C366 vdi.t0 VSS 0.11554f
C367 vdi.t1 VSS 0.11554f
C368 vdi.n60 VSS 0.02425f
C369 vdi.n61 VSS 0.06512f
C370 vdi.n62 VSS 0.04726f
C371 vdi.t8 VSS 0.02311f
C372 vdi.t9 VSS 0.02311f
C373 vdi.n63 VSS 0.15529f
C374 vdi.n64 VSS 0.33164f
C375 vdi.n65 VSS 0.02288f
C376 vdi.n66 VSS 0.02235f
C377 vdi.n67 VSS 0.05152f
C378 vdi.n68 VSS 0.01065f
C379 vdi.n69 VSS 0.02425f
C380 vdi.n70 VSS 0.01893f
C381 vdi.n71 VSS 0.02425f
C382 vdi.n72 VSS 0.01065f
C383 vdi.n73 VSS 0.02425f
C384 vdi.n74 VSS 0.01065f
C385 vdi.n75 VSS 0.02425f
C386 vdi.n76 VSS 0.01065f
C387 vdi.n77 VSS 0.02425f
C388 vdi.n79 VSS 0.02425f
C389 vdi.n80 VSS 0.01065f
C390 vdi.n81 VSS 0.02425f
C391 vdi.n82 VSS 0.01065f
C392 vdi.n83 VSS 0.02425f
C393 vdi.n84 VSS 0.01065f
C394 vdi.n85 VSS 0.02425f
C395 vdi.n86 VSS 0.01065f
C396 vdi.n87 VSS 0.02425f
C397 vdi.n88 VSS 0.01893f
C398 vdi.n89 VSS 0.02425f
C399 vdi.n90 VSS 0.01131f
C400 vdi.n92 VSS 0.01131f
C401 vdi.n93 VSS 0.01131f
C402 vdi.n95 VSS 0.01131f
C403 vdi.n97 VSS 0.01131f
C404 vdi.n99 VSS 0.01131f
C405 vdi.n101 VSS 0.01131f
C406 vdi.n103 VSS 0.01131f
C407 vdi.n105 VSS 0.01131f
C408 vdi.n107 VSS 0.01131f
C409 vdi.n108 VSS 0.01131f
C410 vdi.n116 VSS 0.23108f
C411 vdi.t4 VSS 0.11554f
C412 vdi.t5 VSS 0.11554f
C413 vdi.n117 VSS 0.01065f
C414 vdi.n118 VSS 0.04874f
C415 vdi.n119 VSS 0.02876f
C416 vdi.n120 VSS 0.02222f
C417 vdi.n122 VSS 0.04622f
C418 vdi.t6 VSS 0.02311f
C419 vdi.t7 VSS 0.02311f
C420 vdi.n123 VSS 0.08385f
C421 vdi.n124 VSS 0.10242f
C422 vdi.n125 VSS 0.01035f
C423 vdi.n126 VSS 0.01893f
C424 vdi.n127 VSS 0.02308f
C425 vdi.n128 VSS 0.04501f
C426 vdi.n129 VSS 0.01579f
C427 vdi.n130 VSS 0.01065f
C428 vdi.n131 VSS 0.03792f
C429 vdi.n133 VSS 0.01893f
C430 vdi.n134 VSS 0.01035f
C431 vdi.n135 VSS 0.01893f
C432 vdi.n136 VSS 0.01065f
C433 vdi.n137 VSS 0.01893f
C434 vdi.n138 VSS 0.01065f
C435 vdi.n139 VSS 0.01893f
C436 vdi.n140 VSS 0.01065f
C437 vdi.n141 VSS 0.01893f
C438 vdi.n143 VSS 0.01893f
C439 vdi.n144 VSS 0.01065f
C440 vdi.n145 VSS 0.01893f
C441 vdi.n146 VSS 0.01065f
C442 vdi.n147 VSS 0.01893f
C443 vdi.n148 VSS 0.01065f
C444 vdi.n149 VSS 0.01893f
C445 vdi.n150 VSS 0.01131f
C446 vdi.n152 VSS 0.01131f
C447 vdi.n154 VSS 0.01131f
C448 vdi.n156 VSS 0.01131f
C449 vdi.n158 VSS 0.01131f
C450 vdi.n160 VSS 0.01131f
C451 vdi.n162 VSS 0.01131f
C452 vdi.n164 VSS 0.01131f
C453 vdi.n166 VSS 0.01131f
C454 vdi.n168 VSS 0.01131f
C455 vdi.n170 VSS 0.01131f
C456 vdi.n172 VSS 0.01086f
C457 vdi.n179 VSS 0.23108f
C458 vdi.t3 VSS 0.11554f
C459 vdi.t2 VSS 0.11554f
C460 vdi.n181 VSS 0.01893f
C461 vdi.n182 VSS 0.15722f
C462 vdi.n183 VSS 0.0164f
C463 vdi.n184 VSS 0.02634f
C464 vdi.n185 VSS 0.01131f
C465 vdi.t16 VSS 0.51762f
C466 vdi.n187 VSS 0.27173f
C467 vdi.n188 VSS 0.01028f
C468 vdi.n189 VSS 0.0164f
C469 vdi.n190 VSS 0.02634f
C470 vdi.n191 VSS 0.01131f
C471 vdi.n192 VSS 0.01028f
C472 vdi.t15 VSS 0.51762f
C473 vdi.n194 VSS 0.27173f
C474 vdi.n195 VSS 0.03417f
C475 vdi.n196 VSS 0.0164f
C476 vdi.n197 VSS 0.02634f
C477 vdi.n198 VSS 0.01131f
C478 vdi.n199 VSS 0.01028f
C479 vdi.t14 VSS 0.51762f
C480 vdi.n201 VSS 0.27173f
C481 vdi.n202 VSS 0.03417f
C482 vdi.n203 VSS 0.0164f
C483 vdi.n204 VSS 0.02634f
C484 vdi.n205 VSS 0.01131f
C485 vdi.n206 VSS 0.01028f
C486 vdi.t13 VSS 0.51762f
C487 vdi.n208 VSS 0.27173f
C488 vdi.n209 VSS 0.03417f
C489 vdi.n210 VSS 0.0164f
C490 vdi.n211 VSS 0.02634f
C491 vdi.n212 VSS 0.01131f
C492 vdi.n213 VSS 0.01028f
C493 vdi.t12 VSS 0.51762f
C494 vdi.n215 VSS 0.27173f
C495 vdi.n216 VSS 0.03417f
C496 vdi.n217 VSS 0.01651f
C497 vdi.n218 VSS 0.01131f
C498 vdi.n219 VSS 0.01028f
C499 vdi.t11 VSS 0.51762f
C500 vdi.n221 VSS 0.27173f
C501 vdi.n222 VSS 0.03613f
C502 vdi.n223 VSS 0.06165f
C503 VDD.n0 VSS 0.39117f
C504 VDD.n1 VSS 0.01721f
C505 VDD.n3 VSS 0.01308f
C506 VDD.n4 VSS 0.44023f
C507 VDD.n5 VSS 0.01026f
C508 VDD.n6 VSS 0.01026f
C509 VDD.n7 VSS 0.01026f
C510 VDD.n9 VSS 0.01026f
C511 VDD.n10 VSS 0.01026f
C512 VDD.n12 VSS 0.01729f
C513 VDD.n13 VSS 0.01026f
C514 VDD.n14 VSS 0.01026f
C515 VDD.n15 VSS 0.18112f
C516 VDD.n16 VSS 0.10817f
C517 VDD.n17 VSS 0.01026f
C518 VDD.n18 VSS 0.01729f
C519 VDD.n19 VSS 0.01026f
C520 VDD.n20 VSS 0.01026f
C521 VDD.n21 VSS 0.18112f
C522 VDD.n22 VSS 0.01026f
C523 VDD.n23 VSS 0.01026f
C524 VDD.n24 VSS 0.01026f
C525 VDD.n25 VSS 0.18112f
C526 VDD.n26 VSS 0.01026f
C527 VDD.n27 VSS 0.01026f
C528 VDD.n28 VSS 0.01026f
C529 VDD.n29 VSS 0.18112f
C530 VDD.n30 VSS 0.01026f
C531 VDD.n31 VSS 0.01026f
C532 VDD.n32 VSS 0.01026f
C533 VDD.t24 VSS 0.09056f
C534 VDD.n33 VSS 0.01026f
C535 VDD.n34 VSS 0.01026f
C536 VDD.n35 VSS 0.01026f
C537 VDD.n36 VSS 0.18112f
C538 VDD.n37 VSS 0.01026f
C539 VDD.n38 VSS 0.01026f
C540 VDD.n39 VSS 0.01026f
C541 VDD.n40 VSS 0.18112f
C542 VDD.n41 VSS 0.01026f
C543 VDD.n42 VSS 0.01026f
C544 VDD.n43 VSS 0.01026f
C545 VDD.n44 VSS 0.18112f
C546 VDD.n45 VSS 0.01026f
C547 VDD.n46 VSS 0.01729f
C548 VDD.n47 VSS 0.01729f
C549 VDD.n48 VSS 0.10817f
C550 VDD.n49 VSS 0.01729f
C551 VDD.n50 VSS 0.01026f
C552 VDD.n51 VSS 0.01026f
C553 VDD.n52 VSS 0.19118f
C554 VDD.t21 VSS 0.02608f
C555 VDD.n73 VSS 0.0203f
C556 VDD.n74 VSS 0.01021f
C557 VDD.n83 VSS 0.07842f
C558 VDD.n84 VSS 0.09521f
C559 VDD.n86 VSS 0.01584f
C560 VDD.t1 VSS 0.04346f
C561 VDD.t23 VSS 0.04346f
C562 VDD.n97 VSS 0.17358f
C563 VDD.n98 VSS 0.18112f
C564 VDD.n103 VSS 0.18112f
C565 VDD.n107 VSS 0.18112f
C566 VDD.t2 VSS 0.09056f
C567 VDD.n113 VSS 0.01622f
C568 VDD.n115 VSS 0.18112f
C569 VDD.n116 VSS 0.17358f
C570 VDD.t10 VSS 0.09056f
C571 VDD.n123 VSS 0.18112f
C572 VDD.n124 VSS 0.15848f
C573 VDD.t6 VSS 0.09056f
C574 VDD.n130 VSS 0.01756f
C575 VDD.n132 VSS 0.18112f
C576 VDD.n133 VSS 0.14339f
C577 VDD.t14 VSS 0.09056f
C578 VDD.n139 VSS 0.18112f
C579 VDD.t18 VSS 0.09056f
C580 VDD.n145 VSS 0.0167f
C581 VDD.n147 VSS 0.18112f
C582 VDD.n148 VSS 0.1132f
C583 VDD.t16 VSS 0.09056f
C584 VDD.n155 VSS 0.18112f
C585 VDD.n156 VSS 0.09811f
C586 VDD.n160 VSS 0.09811f
C587 VDD.n164 VSS 0.18112f
C588 VDD.t12 VSS 0.09056f
C589 VDD.n168 VSS 0.1132f
C590 VDD.n172 VSS 0.18112f
C591 VDD.t8 VSS 0.09056f
C592 VDD.n176 VSS 0.1283f
C593 VDD.n180 VSS 0.18112f
C594 VDD.t4 VSS 0.09056f
C595 VDD.n184 VSS 0.29684f
C596 VDD.n219 VSS 0.01634f
C597 VDD.n227 VSS 0.09535f
C598 VDD.t9 VSS 0.04346f
C599 VDD.t13 VSS 0.04346f
C600 VDD.n236 VSS 0.01021f
C601 VDD.n252 VSS 0.03527f
C602 VDD.n253 VSS 0.01021f
C603 VDD.t17 VSS 0.04346f
C604 VDD.t19 VSS 0.04346f
C605 VDD.n277 VSS 0.01584f
C606 VDD.n279 VSS 0.01622f
C607 VDD.n280 VSS 0.08692f
C608 VDD.n285 VSS 0.0203f
C609 VDD.n286 VSS 0.01021f
C610 VDD.t15 VSS 0.04346f
C611 VDD.n296 VSS 0.01593f
C612 VDD.n300 VSS 0.09535f
C613 VDD.t7 VSS 0.04346f
C614 VDD.n313 VSS 0.08692f
C615 VDD.n318 VSS 0.0203f
C616 VDD.n319 VSS 0.01021f
C617 VDD.t11 VSS 0.04346f
C618 VDD.n329 VSS 0.01584f
C619 VDD.t3 VSS 0.04346f
C620 VDD.n345 VSS 0.08692f
C621 VDD.n350 VSS 0.0203f
C622 VDD.n351 VSS 0.01021f
C623 VDD.n368 VSS 0.0203f
C624 VDD.n369 VSS 0.0821f
C625 VDD.n370 VSS 0.08335f
C626 VDD.n371 VSS 0.08349f
C627 VDD.n372 VSS 0.08349f
C628 VDD.n373 VSS 0.15605f
C629 VDD.n385 VSS 0.0203f
C630 VDD.n388 VSS 0.08712f
C631 VDD.n392 VSS 0.04444f
C632 VDD.n393 VSS 0.21152f
C633 VDD.n394 VSS 0.01989f
C634 VDD.t5 VSS 0.02608f
C635 VDD.n398 VSS 0.07823f
C636 VDD.n400 VSS 0.01332f
C637 VDD.n401 VSS 0.01584f
C638 VDD.n405 VSS 0.19118f
C639 VDD.n411 VSS 0.14339f
C640 VDD.n417 VSS 0.18112f
C641 VDD.n423 VSS 0.15848f
C642 VDD.n429 VSS 0.18112f
C643 VDD.n435 VSS 0.17358f
C644 VDD.n441 VSS 0.18112f
C645 VDD.n447 VSS 0.18112f
C646 VDD.n453 VSS 0.17358f
C647 VDD.n459 VSS 0.18112f
C648 VDD.n467 VSS 0.15848f
C649 VDD.n473 VSS 0.18112f
C650 VDD.n474 VSS 0.1283f
C651 VDD.n477 VSS 0.14339f
C652 VDD.n483 VSS 0.18112f
C653 VDD.n486 VSS 0.01883f
C654 VDD.n490 VSS 0.1283f
C655 VDD.n496 VSS 0.18112f
C656 VDD.n502 VSS 0.1132f
C657 VDD.n508 VSS 0.18112f
C658 VDD.n510 VSS 0.0167f
C659 VDD.n514 VSS 0.09811f
C660 VDD.n520 VSS 0.18112f
C661 VDD.t0 VSS 0.09056f
C662 VDD.n526 VSS 0.09811f
C663 VDD.n535 VSS 0.18112f
C664 VDD.n565 VSS 0.18112f
C665 VDD.n566 VSS 0.14339f
C666 VDD.t20 VSS 0.09056f
C667 VDD.n567 VSS 0.1283f
C668 VDD.n573 VSS 0.18112f
C669 VDD.n574 VSS 0.15848f
C670 VDD.t22 VSS 0.09056f
C671 VDD.n575 VSS 0.1132f
C672 VDD.n581 VSS 0.18112f
C673 VDD.n583 VSS 0.0167f
C674 VDD.n584 VSS 0.01622f
C675 VDD.n585 VSS 0.08692f
C676 VDD.n591 VSS 0.48088f
C677 VDD.n592 VSS 0.08315f
C678 VDD.n598 VSS 0.01455f
C679 VDD.n601 VSS 0.01371f
C680 VDD.n617 VSS 0.42136f
C681 VDD.n623 VSS 0.01026f
C682 VDD.n624 VSS 0.01308f
C683 VDD.n625 VSS 0.01308f
C684 VDD.n626 VSS 0.01026f
C685 VDD.n627 VSS 0.01026f
C686 VDD.n628 VSS 0.01026f
C687 VDD.n629 VSS 0.01026f
C688 VDD.n630 VSS 0.01026f
C689 VDD.n631 VSS 0.01026f
C690 VDD.n632 VSS 0.01026f
C691 VDD.n633 VSS 0.01026f
C692 VDD.n634 VSS 0.01026f
C693 VDD.n635 VSS 0.01026f
C694 VDD.n636 VSS 0.01026f
C695 VDD.n637 VSS 0.01026f
C696 VDD.n638 VSS 0.01026f
C697 VDD.n639 VSS 0.01026f
C698 VDD.n640 VSS 0.01026f
C699 VDD.n641 VSS 0.01026f
C700 VDD.n642 VSS 0.01026f
C701 VDD.n643 VSS 0.01026f
C702 VDD.n644 VSS 0.01026f
C703 VDD.n645 VSS 0.33835f
C704 VDD.n647 VSS 0.01308f
C705 VDD.n648 VSS 0.01308f
C706 VDD.n649 VSS 0.01729f
C707 VDD.n650 VSS 0.01026f
C708 VDD.n651 VSS 0.01026f
C709 VDD.n652 VSS 0.18112f
C710 VDD.n653 VSS 0.01026f
C711 VDD.n654 VSS 0.01026f
C712 VDD.n655 VSS 0.01026f
C713 VDD.n656 VSS 0.01026f
C714 VDD.n657 VSS 0.01026f
C715 VDD.n658 VSS 0.18112f
C716 VDD.n659 VSS 0.01026f
C717 VDD.n660 VSS 0.01026f
C718 VDD.n661 VSS 0.01026f
C719 VDD.n662 VSS 0.01026f
C720 VDD.n663 VSS 0.01026f
C721 VDD.n664 VSS 0.18112f
C722 VDD.n665 VSS 0.01026f
C723 VDD.n666 VSS 0.01026f
C724 VDD.n667 VSS 0.01026f
C725 VDD.n668 VSS 0.01026f
C726 VDD.n669 VSS 0.01026f
C727 VDD.n670 VSS 0.17986f
C728 VDD.n671 VSS 0.18112f
C729 VDD.n672 VSS 0.01026f
C730 VDD.n673 VSS 0.01026f
C731 VDD.n674 VSS 0.01026f
C732 VDD.n675 VSS 0.01026f
C733 VDD.n676 VSS 0.01026f
C734 VDD.n677 VSS 0.09182f
C735 VDD.n678 VSS 0.01026f
C736 VDD.n679 VSS 0.01026f
C737 VDD.n680 VSS 0.01026f
C738 VDD.n681 VSS 0.01026f
C739 VDD.n682 VSS 0.01026f
C740 VDD.n683 VSS 0.18112f
C741 VDD.n684 VSS 0.01026f
C742 VDD.n685 VSS 0.01026f
C743 VDD.n686 VSS 0.01026f
C744 VDD.n687 VSS 0.01026f
C745 VDD.n688 VSS 0.01026f
C746 VDD.n689 VSS 0.18112f
C747 VDD.n690 VSS 0.01026f
C748 VDD.n691 VSS 0.01026f
C749 VDD.n692 VSS 0.01026f
C750 VDD.n693 VSS 0.01026f
C751 VDD.n694 VSS 0.01026f
C752 VDD.n695 VSS 0.18112f
C753 VDD.n696 VSS 0.01026f
C754 VDD.n697 VSS 0.01026f
C755 VDD.n698 VSS 0.01026f
C756 VDD.n699 VSS 0.01026f
C757 VDD.n700 VSS 0.01026f
C758 VDD.n701 VSS 0.18112f
C759 VDD.n702 VSS 0.01026f
C760 VDD.n703 VSS 0.01026f
C761 VDD.n704 VSS 0.01729f
C762 VDD.n705 VSS 0.01308f
C763 VDD.n706 VSS 0.01308f
C764 VDD.n708 VSS 0.01026f
C765 VDD.n709 VSS 0.01026f
C766 VDD.n710 VSS 0.01026f
C767 VDD.n711 VSS 0.01026f
C768 VDD.n712 VSS 0.01026f
C769 VDD.n713 VSS 0.01026f
C770 VDD.n715 VSS 0.01026f
C771 VDD.n716 VSS 0.01026f
C772 VDD.n717 VSS 0.01026f
C773 VDD.n718 VSS 0.01026f
C774 VDD.n719 VSS 0.01026f
C775 VDD.n720 VSS 0.01026f
C776 VDD.n722 VSS 0.01026f
C777 VDD.n723 VSS 0.01026f
C778 VDD.n726 VSS 0.02978f
C779 VDD.n727 VSS 0.01749f
C780 VDD.n728 VSS 0.03836f
C781 VR.n2 VSS 0.01123f
C782 VR.t5 VSS 0.07516f
C783 VR.t2 VSS 0.07516f
C784 VR.n3 VSS 0.15738f
C785 VR.n4 VSS 0.03461f
C786 VR.n5 VSS 0.16068f
C787 VR.n6 VSS 0.16068f
C788 VR.n8 VSS 0.01123f
C789 VR.n9 VSS 0.03461f
C790 VR.t0 VSS 0.0451f
C791 VR.n10 VSS 0.14234f
C792 VR.n12 VSS 0.02127f
C793 VR.n13 VSS 0.06341f
C794 VR.t7 VSS 0.15674f
C795 VR.n14 VSS 0.04442f
C796 VR.t8 VSS 0.08268f
C797 VR.n15 VSS 0.10822f
C798 VR.t9 VSS 0.08268f
C799 VR.n17 VSS 0.10822f
C800 VR.t10 VSS 0.08268f
C801 VR.n19 VSS 0.10822f
C802 VR.t11 VSS 0.08268f
C803 VR.n22 VSS 0.10822f
C804 VR.t12 VSS 0.42091f
C805 VR.n24 VSS 0.22096f
C806 VR.n25 VSS 0.0528f
C807 VR.t13 VSS 0.42091f
C808 VR.n26 VSS 0.22096f
C809 VR.n27 VSS 0.0528f
C810 VR.t14 VSS 0.42091f
C811 VR.n28 VSS 0.22096f
C812 VR.t15 VSS 0.42091f
C813 VR.n29 VSS 0.22096f
C814 VR.n31 VSS 0.05689f
C815 VR.t16 VSS 0.49815f
C816 VR.n32 VSS 0.01245f
C817 VR.n34 VSS 0.02841f
C818 VR.n36 VSS 0.02841f
C819 VR.t21 VSS 0.37582f
C820 VR.t20 VSS 0.67647f
C821 VR.t19 VSS 0.67647f
C822 VR.t18 VSS 0.66895f
C823 VR.t17 VSS 0.42467f
C824 VR.n39 VSS 0.02841f
C825 VR.n43 VSS 0.09651f
C826 VR.n44 VSS 0.03169f
C827 VR.n45 VSS 0.07005f
C828 VR.n47 VSS 0.01245f
C829 VR.n48 VSS 0.01245f
C830 VR.n49 VSS 0.05066f
C831 VR.n52 VSS 0.02841f
C832 VR.n53 VSS 0.02131f
C833 VR.n54 VSS 0.10816f
C834 VR.n55 VSS 0.02841f
C835 VR.n56 VSS 0.02131f
C836 VR.n58 VSS 0.01098f
C837 VR.n63 VSS 0.0115f
C838 VR.n65 VSS 0.06374f
C839 VR.n66 VSS 0.0206f
C840 VR.n67 VSS 0.06713f
C841 VR.n68 VSS 0.0863f
C842 VR.n69 VSS 0.15394f
C843 VR.n70 VSS 0.02917f
C844 VR.n71 VSS 0.02938f
C845 VR.n72 VSS 0.0528f
C846 VR.n74 VSS 0.01333f
C847 VR.n75 VSS 0.01982f
C848 VR.n76 VSS 0.02778f
C849 VR.n79 VSS 0.01333f
C850 VR.n80 VSS 0.02142f
C851 VR.n81 VSS 0.02778f
C852 VR.n84 VSS 0.01333f
C853 VR.n85 VSS 0.02142f
C854 VR.n86 VSS 0.02778f
C855 VR.n89 VSS 0.01333f
C856 VR.n90 VSS 0.04387f
C857 VR.n91 VSS 0.05089f
C858 VR.n94 VSS 0.01333f
C859 VR.n95 VSS 0.02153f
C860 VR.n96 VSS 0.02938f
C861 VR.n99 VSS 0.01333f
C862 VR.n100 VSS 0.01982f
C863 VR.n101 VSS 0.02938f
C864 VR.n104 VSS 0.01333f
C865 VR.n105 VSS 0.01982f
C866 VR.n106 VSS 0.02938f
C867 VR.n109 VSS 0.01333f
C868 VR.n110 VSS 0.01982f
C869 VR.n111 VSS 0.03241f
C870 VR.n112 VSS 0.12216f
C871 VR.n113 VSS 0.16068f
C872 VR.n115 VSS 0.01123f
C873 VR.t4 VSS 0.0451f
C874 VR.n116 VSS 0.03461f
C875 VR.n117 VSS 0.14234f
C876 VR.n120 VSS 0.04412f
C877 VR.n121 VSS 0.29288f
C878 VR.n122 VSS 0.16068f
C879 VR.n124 VSS 0.01123f
C880 VR.t1 VSS 0.07516f
C881 VR.n125 VSS 0.03461f
C882 VR.t3 VSS 0.07516f
C883 VR.n126 VSS 0.15738f
C884 VR.n129 VSS 0.04412f
C885 VR.n130 VSS 0.13161f
C886 VR.t6 VSS 0.07835f
C887 VR.n131 VSS 0.1819f
C888 VR.n132 VSS 0.21396f
C889 VR.n133 VSS 0.04412f
C890 VR.n134 VSS 0.02127f
.ends
