* NGSPICE file created from OTA.ext - technology: sky130A

.subckt OTA VDD VO_ota VIN_ota VIP_ota VSS VGN
X0 VO_ota.t4 vgp.t8 VDD.t10 VDD.t9 sky130_fd_pr__pfet_01v8_lvt ad=1.5625 pd=6.75 as=1.5625 ps=6.75 w=6.25 l=2
X1 VDD.t35 vgp.t5 VO_ota.t16 VDD.t34 sky130_fd_pr__pfet_01v8_lvt ad=1.875 pd=13.1 as=1.5625 ps=6.75 w=6.25 l=2
X2 a_4664_n951.t1 a_8092_n697.t0 VSS.t14 sky130_fd_pr__res_xhigh_po_0p35 l=15.12
X3 VSS.t5 vd.t4 vd.t5 VSS.t4 sky130_fd_pr__nfet_01v8 ad=0.375 pd=2 as=0.45 ps=3.6 w=1.5 l=1
X4 a_4664_n1459.t1 a_8092_n1713.t1 VSS.t2 sky130_fd_pr__res_xhigh_po_0p35 l=15.12
X5 vtail.t10 vgp.t18 VDD.t11 VDD.t1 sky130_fd_pr__pfet_01v8_lvt ad=1.5625 pd=6.75 as=1.5625 ps=6.75 w=6.25 l=1
X6 vd.t1 VIN_ota.t2 vtail.t5 VDD.t17 sky130_fd_pr__pfet_01v8_lvt ad=1.625 pd=7 as=1.625 ps=7 w=6.5 l=1
X7 VSS.t22 vo1.t11 VO_ota.t13 VSS.t0 sky130_fd_pr__nfet_01v8 ad=0.25 pd=1.5 as=0.25 ps=1.5 w=1 l=2
X8 vtail.t8 vgp.t20 VDD.t30 VDD.t16 sky130_fd_pr__pfet_01v8_lvt ad=1.5625 pd=6.75 as=3.5 ps=13.62 w=6.25 l=1
X9 VDD.t6 vgp.t15 vtail.t13 VDD.t2 sky130_fd_pr__pfet_01v8_lvt ad=1.5625 pd=6.75 as=1.5625 ps=6.75 w=6.25 l=1
X10 vd.t7 vd.t6 VSS.t17 VSS.t16 sky130_fd_pr__nfet_01v8 ad=0.375 pd=2 as=0.375 ps=2 w=1.5 l=1
X11 VDD.t33 vgp.t2 vgp.t3 VDD.t32 sky130_fd_pr__pfet_01v8_lvt ad=1.875 pd=13.1 as=1.5625 ps=6.75 w=6.25 l=1
X12 VDD.t20 vgp.t17 vtail.t11 VDD.t17 sky130_fd_pr__pfet_01v8_lvt ad=1.5625 pd=6.75 as=1.5625 ps=6.75 w=6.25 l=1
X13 vo1.t6 a_8092_n697.t1 VSS.t23 sky130_fd_pr__res_xhigh_po_0p35 l=15.12
X14 VSS.t25 vd.t12 vo1.t7 VSS.t24 sky130_fd_pr__nfet_01v8 ad=0.375 pd=2 as=0.375 ps=2 w=1.5 l=1
X15 vtail.t14 vgp.t14 VDD.t29 VDD.t3 sky130_fd_pr__pfet_01v8_lvt ad=1.5625 pd=6.75 as=1.5625 ps=6.75 w=6.25 l=1
X16 vtail.t3 VIP_ota.t0 vo1.t0 VDD.t3 sky130_fd_pr__pfet_01v8_lvt ad=1.625 pd=7 as=1.625 ps=7 w=6.5 l=1
X17 vmiler.t1 VO_ota.t6 sky130_fd_pr__cap_mim_m3_2 l=56 w=44.6
X18 VO_ota.t11 vgp.t10 VDD.t28 VDD.t27 sky130_fd_pr__pfet_01v8_lvt ad=1.5625 pd=6.75 as=1.5625 ps=6.75 w=6.25 l=2
X19 VO_ota.t7 vo1.t12 VSS.t11 VSS.t0 sky130_fd_pr__nfet_01v8 ad=0.25 pd=1.5 as=0.25 ps=1.5 w=1 l=2
X20 vtail.t12 vgp.t16 VDD.t21 VDD.t18 sky130_fd_pr__pfet_01v8_lvt ad=1.5625 pd=6.75 as=1.5625 ps=6.75 w=6.25 l=1
X21 VDD.t5 vgp.t7 VO_ota.t1 VDD.t4 sky130_fd_pr__pfet_01v8_lvt ad=1.5625 pd=6.75 as=1.5625 ps=6.75 w=6.25 l=2
X22 a_4664_n951.t0 a_8092_n1205.t0 VSS.t8 sky130_fd_pr__res_xhigh_po_0p35 l=15.12
X23 vmiler.t0 a_8092_n1713.t0 VSS.t2 sky130_fd_pr__res_xhigh_po_0p35 l=15.12
X24 vtail.t6 VIN_ota.t1 vd.t3 VDD.t18 sky130_fd_pr__pfet_01v8_lvt ad=1.625 pd=7 as=1.625 ps=7 w=6.5 l=1
X25 VDD.t22 vgp.t13 vtail.t15 VDD.t19 sky130_fd_pr__pfet_01v8_lvt ad=3.25 pd=13.54 as=1.5625 ps=6.75 w=6.25 l=1
X26 VSS.t1 vo1.t13 VO_ota.t0 VSS.t0 sky130_fd_pr__nfet_01v8 ad=0.25 pd=1.5 as=0.25 ps=1.5 w=1 l=2
X27 VSS.t10 vd.t14 vo1.t4 VSS.t9 sky130_fd_pr__nfet_01v8 ad=0.375 pd=2 as=0.375 ps=2 w=1.5 l=1
X28 vd.t2 VIN_ota.t0 vtail.t7 VDD.t19 sky130_fd_pr__pfet_01v8_lvt ad=1.95 pd=13.6 as=1.625 ps=7 w=6.5 l=1
X29 vo1.t5 vd.t13 VSS.t21 VSS.t20 sky130_fd_pr__nfet_01v8 ad=0.375 pd=2 as=0.375 ps=2 w=1.5 l=1
X30 VO_ota.t5 vgp.t12 VDD.t13 VDD.t12 sky130_fd_pr__pfet_01v8_lvt ad=1.5625 pd=6.75 as=1.875 ps=13.1 w=6.25 l=2
X31 VDD.t24 vgp.t9 VO_ota.t9 VDD.t23 sky130_fd_pr__pfet_01v8_lvt ad=1.5625 pd=6.75 as=1.5625 ps=6.75 w=6.25 l=2
X32 vo1.t3 VIP_ota.t3 vtail.t0 VDD.t0 sky130_fd_pr__pfet_01v8_lvt ad=1.625 pd=7 as=1.625 ps=7 w=6.5 l=1
X33 VO_ota.t8 vo1.t14 VSS.t15 VSS.t0 sky130_fd_pr__nfet_01v8 ad=0.25 pd=1.5 as=0.25 ps=1.5 w=1 l=2
X34 vgp.t4 VGN.t0 VSS.t28 VSS.t27 sky130_fd_pr__nfet_01v8 ad=2.4 pd=16.6 as=2.4 ps=16.6 w=8 l=1
X35 VSS.t29 vo1.t15 VO_ota.t15 VSS.t0 sky130_fd_pr__nfet_01v8 ad=0.25 pd=1.5 as=0.25 ps=1.5 w=1 l=2
X36 vo1.t8 vd.t15 VSS.t31 VSS.t30 sky130_fd_pr__nfet_01v8 ad=0.375 pd=2 as=0.375 ps=2 w=1.5 l=1
X37 VDD.t26 vgp.t11 VO_ota.t10 VDD.t25 sky130_fd_pr__pfet_01v8_lvt ad=1.5625 pd=6.75 as=1.5625 ps=6.75 w=6.25 l=2
X38 VO_ota.t14 vo1.t16 VSS.t26 VSS.t0 sky130_fd_pr__nfet_01v8 ad=0.25 pd=1.5 as=0.3 ps=2.6 w=1 l=2
X39 VO_ota.t3 vgp.t6 VDD.t8 VDD.t7 sky130_fd_pr__pfet_01v8_lvt ad=1.5625 pd=6.75 as=1.5625 ps=6.75 w=6.25 l=2
X40 vtail.t1 VIP_ota.t2 vo1.t1 VDD.t1 sky130_fd_pr__pfet_01v8_lvt ad=1.625 pd=7 as=1.625 ps=7 w=6.5 l=1
X41 a_4664_n1459.t0 a_8092_n1205.t1 VSS.t18 sky130_fd_pr__res_xhigh_po_0p35 l=15.12
X42 VSS.t3 vo1.t9 VO_ota.t2 VSS.t0 sky130_fd_pr__nfet_01v8 ad=0.3 pd=2.6 as=0.25 ps=1.5 w=1 l=2
X43 VSS.t13 vd.t8 vd.t9 VSS.t12 sky130_fd_pr__nfet_01v8 ad=0.375 pd=2 as=0.375 ps=2 w=1.5 l=1
X44 vtail.t4 VIN_ota.t3 vd.t0 VDD.t16 sky130_fd_pr__pfet_01v8_lvt ad=1.625 pd=7 as=1.95 ps=13.6 w=6.5 l=1
X45 vd.t11 vd.t10 VSS.t7 VSS.t6 sky130_fd_pr__nfet_01v8 ad=0.45 pd=3.6 as=0.375 ps=2 w=1.5 l=1
X46 vo1.t2 VIP_ota.t1 vtail.t2 VDD.t2 sky130_fd_pr__pfet_01v8_lvt ad=1.625 pd=7 as=1.625 ps=7 w=6.5 l=1
X47 VDD.t31 vgp.t19 vtail.t9 VDD.t0 sky130_fd_pr__pfet_01v8_lvt ad=1.5625 pd=6.75 as=1.5625 ps=6.75 w=6.25 l=1
X48 vgp.t1 vgp.t0 VDD.t15 VDD.t14 sky130_fd_pr__pfet_01v8_lvt ad=1.5625 pd=6.75 as=1.875 ps=13.1 w=6.25 l=1
X49 VO_ota.t12 vo1.t10 VSS.t19 VSS.t0 sky130_fd_pr__nfet_01v8 ad=0.25 pd=1.5 as=0.25 ps=1.5 w=1 l=2
R0 VIP_ota.n8 VIP_ota.n7 184.74
R1 VIP_ota.n25 VIP_ota.n23 184.74
R2 VIP_ota.n34 VIP_ota.n33 184.74
R3 VIP_ota.n15 VIP_ota.n13 184.74
R4 VIP_ota.n7 VIP_ota.t3 156.65
R5 VIP_ota.n25 VIP_ota.t1 156.65
R6 VIP_ota.n34 VIP_ota.t0 156.65
R7 VIP_ota.n15 VIP_ota.t2 156.65
R8 VIP_ota.n7 VIP_ota.n6 77.1778
R9 VIP_ota.n26 VIP_ota.n25 77.1778
R10 VIP_ota.n35 VIP_ota.n34 77.1778
R11 VIP_ota.n16 VIP_ota.n15 77.1778
R12 VIP_ota.n8 VIP_ota.n5 27.1064
R13 VIP_ota.n27 VIP_ota.n23 27.1064
R14 VIP_ota.n33 VIP_ota.n1 27.1064
R15 VIP_ota.n14 VIP_ota.n13 27.1064
R16 VIP_ota.n17 VIP_ota.n16 23.1927
R17 VIP_ota.n6 VIP_ota.n3 23.1873
R18 VIP_ota VIP_ota.n35 23.1795
R19 VIP_ota.n26 VIP_ota.n24 23.0979
R20 VIP_ota.n6 VIP_ota.n5 11.3247
R21 VIP_ota.n27 VIP_ota.n26 11.3247
R22 VIP_ota.n35 VIP_ota.n1 11.3247
R23 VIP_ota.n16 VIP_ota.n14 11.3247
R24 VIP_ota.n28 VIP_ota.n23 9.42945
R25 VIP_ota.n9 VIP_ota.n8 9.33838
R26 VIP_ota.n33 VIP_ota.n32 9.33459
R27 VIP_ota.n18 VIP_ota.n13 9.33459
R28 VIP_ota.n5 VIP_ota.n4 9.3005
R29 VIP_ota VIP_ota.n27 9.3005
R30 VIP_ota.n2 VIP_ota.n1 9.3005
R31 VIP_ota VIP_ota.n14 9.3005
R32 VIP_ota.n10 VIP_ota.n9 4.56105
R33 VIP_ota.n32 VIP_ota.n31 4.56105
R34 VIP_ota.n10 VIP_ota.n3 4.56007
R35 VIP_ota.n31 VIP_ota.n0 4.56007
R36 VIP_ota.n24 VIP_ota.n22 4.5005
R37 VIP_ota.n29 VIP_ota.n28 4.5005
R38 VIP_ota.n17 VIP_ota.n12 4.5005
R39 VIP_ota.n19 VIP_ota.n18 4.5005
R40 VIP_ota.n30 VIP_ota.n29 3.42565
R41 VIP_ota.n22 VIP_ota.n21 3.42565
R42 VIP_ota.n20 VIP_ota.n19 3.42565
R43 VIP_ota.n12 VIP_ota.n11 3.42565
R44 VIP_ota.n31 VIP_ota.n30 1.89903
R45 VIP_ota.n11 VIP_ota.n10 1.89746
R46 VIP_ota.n21 VIP_ota.n20 0.60267
R47 VIP_ota.n29 VIP_ota.n22 0.121712
R48 VIP_ota.n19 VIP_ota.n12 0.121712
R49 VIP_ota VIP_ota.n24 0.102773
R50 VIP_ota.n32 VIP_ota.n2 0.102773
R51 VIP_ota.n18 VIP_ota 0.102773
R52 VIP_ota.n9 VIP_ota 0.0667879
R53 VIP_ota.n30 VIP_ota.n21 0.0574697
R54 VIP_ota.n20 VIP_ota.n11 0.0574697
R55 VIP_ota.n4 VIP_ota 0.032697
R56 VIP_ota.n4 VIP_ota.n3 0.0232273
R57 VIP_ota.n28 VIP_ota 0.0194394
R58 VIP_ota.n2 VIP_ota.n0 0.0194394
R59 VIP_ota VIP_ota.n17 0.0194394
R60 VIP_ota VIP_ota.n0 0.0137576
R61 VIN_ota.n10 VIN_ota.n9 184.74
R62 VIN_ota.n19 VIN_ota.n18 184.74
R63 VIN_ota.n26 VIN_ota.n25 184.74
R64 VIN_ota.n5 VIN_ota.n4 184.74
R65 VIN_ota.n10 VIN_ota.t1 156.65
R66 VIN_ota.n19 VIN_ota.t2 156.65
R67 VIN_ota.n25 VIN_ota.t3 156.65
R68 VIN_ota.n5 VIN_ota.t0 156.65
R69 VIN_ota.n11 VIN_ota.n10 77.1778
R70 VIN_ota.n20 VIN_ota.n19 77.1778
R71 VIN_ota.n25 VIN_ota.n24 77.1778
R72 VIN_ota.n6 VIN_ota.n5 77.1778
R73 VIN_ota.n12 VIN_ota.n9 27.1064
R74 VIN_ota.n18 VIN_ota.n17 27.1064
R75 VIN_ota.n26 VIN_ota.n1 27.1064
R76 VIN_ota.n4 VIN_ota.n3 27.1064
R77 VIN_ota.n11 VIN_ota 23.2132
R78 VIN_ota.n21 VIN_ota.n20 23.2051
R79 VIN_ota.n24 VIN_ota.n23 23.2051
R80 VIN_ota.n7 VIN_ota.n6 23.076
R81 VIN_ota.n12 VIN_ota.n11 11.3247
R82 VIN_ota.n20 VIN_ota.n17 11.3247
R83 VIN_ota.n24 VIN_ota.n1 11.3247
R84 VIN_ota.n6 VIN_ota.n3 11.3247
R85 VIN_ota.n18 VIN_ota 9.44996
R86 VIN_ota VIN_ota.n26 9.44996
R87 VIN_ota.n14 VIN_ota.n9 9.44181
R88 VIN_ota.n4 VIN_ota.n2 9.37115
R89 VIN_ota.n13 VIN_ota.n12 9.3005
R90 VIN_ota.n17 VIN_ota.n16 9.3005
R91 VIN_ota.n1 VIN_ota.n0 9.3005
R92 VIN_ota.n3 VIN_ota 9.3005
R93 VIN_ota.n23 VIN_ota.n22 4.69504
R94 VIN_ota.n8 VIN_ota.n2 4.56105
R95 VIN_ota.n8 VIN_ota.n7 4.56007
R96 VIN_ota.n15 VIN_ota.n14 4.03223
R97 VIN_ota.n22 VIN_ota.n21 4.03067
R98 VIN_ota.n15 VIN_ota.n8 2.33041
R99 VIN_ota.n22 VIN_ota.n15 0.255978
R100 VIN_ota.n14 VIN_ota.n13 0.0548478
R101 VIN_ota.n21 VIN_ota.n16 0.0548478
R102 VIN_ota.n23 VIN_ota.n0 0.0548478
R103 VIN_ota.n13 VIN_ota 0.0466957
R104 VIN_ota VIN_ota.n16 0.0466957
R105 VIN_ota VIN_ota.n0 0.0466957
R106 VIN_ota.n7 VIN_ota 0.0371848
R107 VIN_ota VIN_ota.n2 0.00729348
R108 VGN.n2 VGN.t0 192.8
R109 VGN.n2 VGN.n1 184.74
R110 VGN.n3 VGN.n2 77.1778
R111 VGN.n4 VGN.n1 27.1064
R112 VGN.n6 VGN.n3 23.0752
R113 VGN.n4 VGN.n3 11.3247
R114 VGN.n8 VGN.n1 9.30732
R115 VGN.n5 VGN.n4 9.3005
R116 VGN.n7 VGN.n6 4.62057
R117 VGN.n8 VGN.n7 4.62057
R118 VGN.n7 VGN.n0 4.50182
R119 VGN.n6 VGN.n5 0.0709545
R120 VGN VGN.n8 0.0686818
R121 VGN VGN.n0 0.00504545
R122 VGN.n5 VGN.n0 0.00277273
R123 VO_ota.n257 VO_ota.n256 585
R124 VO_ota.n174 VO_ota.n173 585
R125 VO_ota.n93 VO_ota.n92 585
R126 VO_ota.n305 VO_ota.n304 585
R127 VO_ota.n257 VO_ota.n196 285.877
R128 VO_ota.n257 VO_ota.n195 285.877
R129 VO_ota.n257 VO_ota.n194 285.877
R130 VO_ota.n257 VO_ota.n193 285.877
R131 VO_ota.n257 VO_ota.n192 285.877
R132 VO_ota.n257 VO_ota.n191 285.877
R133 VO_ota.n257 VO_ota.n190 285.877
R134 VO_ota.n258 VO_ota.n257 285.877
R135 VO_ota.n174 VO_ota.n113 285.877
R136 VO_ota.n174 VO_ota.n112 285.877
R137 VO_ota.n174 VO_ota.n111 285.877
R138 VO_ota.n174 VO_ota.n110 285.877
R139 VO_ota.n174 VO_ota.n109 285.877
R140 VO_ota.n174 VO_ota.n108 285.877
R141 VO_ota.n174 VO_ota.n107 285.877
R142 VO_ota.n175 VO_ota.n174 285.877
R143 VO_ota.n93 VO_ota.n33 285.877
R144 VO_ota.n93 VO_ota.n32 285.877
R145 VO_ota.n93 VO_ota.n31 285.877
R146 VO_ota.n93 VO_ota.n30 285.877
R147 VO_ota.n93 VO_ota.n29 285.877
R148 VO_ota.n93 VO_ota.n28 285.877
R149 VO_ota.n93 VO_ota.n27 285.877
R150 VO_ota.n94 VO_ota.n93 285.877
R151 VO_ota.n305 VO_ota.n275 285.877
R152 VO_ota.n305 VO_ota.n274 285.877
R153 VO_ota.n305 VO_ota.n273 285.877
R154 VO_ota.n305 VO_ota.n5 285.877
R155 VO_ota.n305 VO_ota.n6 285.877
R156 VO_ota.n306 VO_ota.n305 285.877
R157 VO_ota.n305 VO_ota.n270 285.877
R158 VO_ota.n305 VO_ota.n12 285.877
R159 VO_ota.n262 VO_ota.n261 99.2758
R160 VO_ota.n182 VO_ota.n181 86.1871
R161 VO_ota.n99 VO_ota.n98 86.1871
R162 VO_ota.n21 VO_ota.n20 86.1871
R163 VO_ota.n261 VO_ota.t0 30.0005
R164 VO_ota.n261 VO_ota.t8 30.0005
R165 VO_ota.n181 VO_ota.t13 30.0005
R166 VO_ota.n181 VO_ota.t7 30.0005
R167 VO_ota.n98 VO_ota.t2 30.0005
R168 VO_ota.n98 VO_ota.t12 30.0005
R169 VO_ota.n20 VO_ota.t15 30.0005
R170 VO_ota.n20 VO_ota.t14 30.0005
R171 VO_ota.n256 VO_ota.n197 27.1064
R172 VO_ota.n251 VO_ota.n250 27.1064
R173 VO_ota.n243 VO_ota.n242 27.1064
R174 VO_ota.n239 VO_ota.n238 27.1064
R175 VO_ota.n230 VO_ota.n229 27.1064
R176 VO_ota.n226 VO_ota.n225 27.1064
R177 VO_ota.n218 VO_ota.n217 27.1064
R178 VO_ota.n214 VO_ota.n189 27.1064
R179 VO_ota.n173 VO_ota.n114 27.1064
R180 VO_ota.n168 VO_ota.n167 27.1064
R181 VO_ota.n160 VO_ota.n159 27.1064
R182 VO_ota.n156 VO_ota.n155 27.1064
R183 VO_ota.n147 VO_ota.n146 27.1064
R184 VO_ota.n143 VO_ota.n142 27.1064
R185 VO_ota.n135 VO_ota.n134 27.1064
R186 VO_ota.n131 VO_ota.n106 27.1064
R187 VO_ota.n92 VO_ota.n34 27.1064
R188 VO_ota.n87 VO_ota.n86 27.1064
R189 VO_ota.n79 VO_ota.n78 27.1064
R190 VO_ota.n75 VO_ota.n74 27.1064
R191 VO_ota.n67 VO_ota.n66 27.1064
R192 VO_ota.n63 VO_ota.n62 27.1064
R193 VO_ota.n55 VO_ota.n54 27.1064
R194 VO_ota.n51 VO_ota.n26 27.1064
R195 VO_ota.n304 VO_ota.n276 27.1064
R196 VO_ota.n304 VO_ota.n277 27.1064
R197 VO_ota.n297 VO_ota.n296 27.1064
R198 VO_ota.n289 VO_ota.n288 27.1064
R199 VO_ota.n272 VO_ota.n271 27.1064
R200 VO_ota.n315 VO_ota.n314 27.1064
R201 VO_ota.n307 VO_ota.n10 27.1064
R202 VO_ota.n269 VO_ota.n11 27.1064
R203 VO_ota.n281 VO_ota.n12 22.6101
R204 VO_ota.n259 VO_ota.n258 22.5471
R205 VO_ota.n176 VO_ota.n175 22.5471
R206 VO_ota.n95 VO_ota.n94 22.5471
R207 VO_ota.n270 VO_ota.n13 22.5471
R208 VO_ota.n99 VO_ota.n97 21.9649
R209 VO_ota.n182 VO_ota.n180 21.9288
R210 VO_ota.n183 VO_ota.n182 21.9288
R211 VO_ota.n100 VO_ota.n99 21.9288
R212 VO_ota.n21 VO_ota.n19 21.9288
R213 VO_ota.n22 VO_ota.n21 21.9288
R214 VO_ota.n251 VO_ota.n196 13.2471
R215 VO_ota.n242 VO_ota.n195 13.2471
R216 VO_ota.n239 VO_ota.n194 13.2471
R217 VO_ota.n229 VO_ota.n193 13.2471
R218 VO_ota.n226 VO_ota.n192 13.2471
R219 VO_ota.n217 VO_ota.n191 13.2471
R220 VO_ota.n214 VO_ota.n190 13.2471
R221 VO_ota.n197 VO_ota.n196 13.2471
R222 VO_ota.n250 VO_ota.n195 13.2471
R223 VO_ota.n243 VO_ota.n194 13.2471
R224 VO_ota.n238 VO_ota.n193 13.2471
R225 VO_ota.n230 VO_ota.n192 13.2471
R226 VO_ota.n225 VO_ota.n191 13.2471
R227 VO_ota.n218 VO_ota.n190 13.2471
R228 VO_ota.n258 VO_ota.n189 13.2471
R229 VO_ota.n168 VO_ota.n113 13.2471
R230 VO_ota.n159 VO_ota.n112 13.2471
R231 VO_ota.n156 VO_ota.n111 13.2471
R232 VO_ota.n146 VO_ota.n110 13.2471
R233 VO_ota.n143 VO_ota.n109 13.2471
R234 VO_ota.n134 VO_ota.n108 13.2471
R235 VO_ota.n131 VO_ota.n107 13.2471
R236 VO_ota.n114 VO_ota.n113 13.2471
R237 VO_ota.n167 VO_ota.n112 13.2471
R238 VO_ota.n160 VO_ota.n111 13.2471
R239 VO_ota.n155 VO_ota.n110 13.2471
R240 VO_ota.n147 VO_ota.n109 13.2471
R241 VO_ota.n142 VO_ota.n108 13.2471
R242 VO_ota.n135 VO_ota.n107 13.2471
R243 VO_ota.n175 VO_ota.n106 13.2471
R244 VO_ota.n87 VO_ota.n33 13.2471
R245 VO_ota.n78 VO_ota.n32 13.2471
R246 VO_ota.n75 VO_ota.n31 13.2471
R247 VO_ota.n66 VO_ota.n30 13.2471
R248 VO_ota.n63 VO_ota.n29 13.2471
R249 VO_ota.n54 VO_ota.n28 13.2471
R250 VO_ota.n51 VO_ota.n27 13.2471
R251 VO_ota.n34 VO_ota.n33 13.2471
R252 VO_ota.n86 VO_ota.n32 13.2471
R253 VO_ota.n79 VO_ota.n31 13.2471
R254 VO_ota.n74 VO_ota.n30 13.2471
R255 VO_ota.n67 VO_ota.n29 13.2471
R256 VO_ota.n62 VO_ota.n28 13.2471
R257 VO_ota.n55 VO_ota.n27 13.2471
R258 VO_ota.n94 VO_ota.n26 13.2471
R259 VO_ota.n297 VO_ota.n275 13.2471
R260 VO_ota.n288 VO_ota.n274 13.2471
R261 VO_ota.n273 VO_ota.n272 13.2471
R262 VO_ota.n315 VO_ota.n5 13.2471
R263 VO_ota.n10 VO_ota.n6 13.2471
R264 VO_ota.n306 VO_ota.n11 13.2471
R265 VO_ota.n276 VO_ota.n12 13.2471
R266 VO_ota.n277 VO_ota.n275 13.2471
R267 VO_ota.n296 VO_ota.n274 13.2471
R268 VO_ota.n289 VO_ota.n273 13.2471
R269 VO_ota.n271 VO_ota.n5 13.2471
R270 VO_ota.n314 VO_ota.n6 13.2471
R271 VO_ota.n307 VO_ota.n306 13.2471
R272 VO_ota.n270 VO_ota.n269 13.2471
R273 VO_ota.n256 VO_ota.n255 9.3635
R274 VO_ota.n173 VO_ota.n172 9.3635
R275 VO_ota.n92 VO_ota.n91 9.3635
R276 VO_ota.n198 VO_ota.n197 9.3005
R277 VO_ota.n252 VO_ota.n251 9.3005
R278 VO_ota.n250 VO_ota.n249 9.3005
R279 VO_ota.n242 VO_ota.n201 9.3005
R280 VO_ota.n244 VO_ota.n243 9.3005
R281 VO_ota.n240 VO_ota.n239 9.3005
R282 VO_ota.n238 VO_ota.n237 9.3005
R283 VO_ota.n229 VO_ota.n204 9.3005
R284 VO_ota.n231 VO_ota.n230 9.3005
R285 VO_ota.n227 VO_ota.n226 9.3005
R286 VO_ota.n225 VO_ota.n224 9.3005
R287 VO_ota.n217 VO_ota.n208 9.3005
R288 VO_ota.n219 VO_ota.n218 9.3005
R289 VO_ota.n215 VO_ota.n214 9.3005
R290 VO_ota.n211 VO_ota.n189 9.3005
R291 VO_ota.n115 VO_ota.n114 9.3005
R292 VO_ota.n169 VO_ota.n168 9.3005
R293 VO_ota.n167 VO_ota.n166 9.3005
R294 VO_ota.n159 VO_ota.n118 9.3005
R295 VO_ota.n161 VO_ota.n160 9.3005
R296 VO_ota.n157 VO_ota.n156 9.3005
R297 VO_ota.n155 VO_ota.n154 9.3005
R298 VO_ota.n146 VO_ota.n121 9.3005
R299 VO_ota.n148 VO_ota.n147 9.3005
R300 VO_ota.n144 VO_ota.n143 9.3005
R301 VO_ota.n142 VO_ota.n141 9.3005
R302 VO_ota.n134 VO_ota.n125 9.3005
R303 VO_ota.n136 VO_ota.n135 9.3005
R304 VO_ota.n132 VO_ota.n131 9.3005
R305 VO_ota.n128 VO_ota.n106 9.3005
R306 VO_ota.n35 VO_ota.n34 9.3005
R307 VO_ota.n88 VO_ota.n87 9.3005
R308 VO_ota.n86 VO_ota.n85 9.3005
R309 VO_ota.n78 VO_ota.n38 9.3005
R310 VO_ota.n80 VO_ota.n79 9.3005
R311 VO_ota.n76 VO_ota.n75 9.3005
R312 VO_ota.n74 VO_ota 9.3005
R313 VO_ota.n66 VO_ota.n41 9.3005
R314 VO_ota.n68 VO_ota.n67 9.3005
R315 VO_ota.n64 VO_ota.n63 9.3005
R316 VO_ota.n62 VO_ota.n61 9.3005
R317 VO_ota.n54 VO_ota.n45 9.3005
R318 VO_ota.n56 VO_ota.n55 9.3005
R319 VO_ota.n52 VO_ota.n51 9.3005
R320 VO_ota.n48 VO_ota.n26 9.3005
R321 VO_ota.n269 VO_ota.n268 9.3005
R322 VO_ota.n14 VO_ota.n11 9.3005
R323 VO_ota.n308 VO_ota.n307 9.3005
R324 VO_ota.n10 VO_ota.n7 9.3005
R325 VO_ota.n314 VO_ota.n313 9.3005
R326 VO_ota.n316 VO_ota.n315 9.3005
R327 VO_ota.n271 VO_ota.n1 9.3005
R328 VO_ota.n272 VO_ota.n0 9.3005
R329 VO_ota.n290 VO_ota.n289 9.3005
R330 VO_ota.n288 VO_ota.n285 9.3005
R331 VO_ota.n296 VO_ota.n295 9.3005
R332 VO_ota.n298 VO_ota.n297 9.3005
R333 VO_ota.n279 VO_ota.n277 9.3005
R334 VO_ota.n304 VO_ota.n303 9.3005
R335 VO_ota.n280 VO_ota.n276 9.3005
R336 VO_ota.n257 VO_ota.t9 7.8805
R337 VO_ota.n257 VO_ota.t11 7.8805
R338 VO_ota.n174 VO_ota.t1 7.8805
R339 VO_ota.n174 VO_ota.t4 7.8805
R340 VO_ota.n93 VO_ota.t16 7.8805
R341 VO_ota.n93 VO_ota.t3 7.8805
R342 VO_ota.n305 VO_ota.t10 7.8805
R343 VO_ota.n305 VO_ota.t5 7.8805
R344 VO_ota.n180 VO_ota.n178 4.68019
R345 VO_ota.n19 VO_ota.n17 4.68019
R346 VO_ota.n184 VO_ota.n183 4.55519
R347 VO_ota.n101 VO_ota.n100 4.55519
R348 VO_ota.n23 VO_ota.n22 4.55519
R349 VO_ota.n188 VO_ota.n187 4.5005
R350 VO_ota.n213 VO_ota.n212 4.5005
R351 VO_ota.n216 VO_ota.n210 4.5005
R352 VO_ota.n221 VO_ota.n220 4.5005
R353 VO_ota.n223 VO_ota.n222 4.5005
R354 VO_ota.n209 VO_ota.n207 4.5005
R355 VO_ota.n228 VO_ota.n206 4.5005
R356 VO_ota.n233 VO_ota.n232 4.5005
R357 VO_ota.n234 VO_ota.n204 4.5005
R358 VO_ota.n236 VO_ota.n235 4.5005
R359 VO_ota.n205 VO_ota.n203 4.5005
R360 VO_ota.n241 VO_ota.n202 4.5005
R361 VO_ota.n246 VO_ota.n245 4.5005
R362 VO_ota.n248 VO_ota.n247 4.5005
R363 VO_ota.n200 VO_ota.n199 4.5005
R364 VO_ota.n254 VO_ota.n253 4.5005
R365 VO_ota.n260 VO_ota.n259 4.5005
R366 VO_ota.n105 VO_ota.n104 4.5005
R367 VO_ota.n130 VO_ota.n129 4.5005
R368 VO_ota.n133 VO_ota.n127 4.5005
R369 VO_ota.n138 VO_ota.n137 4.5005
R370 VO_ota.n140 VO_ota.n139 4.5005
R371 VO_ota.n126 VO_ota.n124 4.5005
R372 VO_ota.n145 VO_ota.n123 4.5005
R373 VO_ota.n150 VO_ota.n149 4.5005
R374 VO_ota.n151 VO_ota.n121 4.5005
R375 VO_ota.n153 VO_ota.n152 4.5005
R376 VO_ota.n122 VO_ota.n120 4.5005
R377 VO_ota.n158 VO_ota.n119 4.5005
R378 VO_ota.n163 VO_ota.n162 4.5005
R379 VO_ota.n165 VO_ota.n164 4.5005
R380 VO_ota.n117 VO_ota.n116 4.5005
R381 VO_ota.n171 VO_ota.n170 4.5005
R382 VO_ota.n177 VO_ota.n176 4.5005
R383 VO_ota.n179 VO_ota.n178 4.5005
R384 VO_ota.n25 VO_ota.n24 4.5005
R385 VO_ota.n50 VO_ota.n49 4.5005
R386 VO_ota.n53 VO_ota.n47 4.5005
R387 VO_ota.n58 VO_ota.n57 4.5005
R388 VO_ota.n60 VO_ota.n59 4.5005
R389 VO_ota.n46 VO_ota.n44 4.5005
R390 VO_ota.n65 VO_ota.n43 4.5005
R391 VO_ota.n70 VO_ota.n69 4.5005
R392 VO_ota.n71 VO_ota.n41 4.5005
R393 VO_ota.n73 VO_ota.n72 4.5005
R394 VO_ota.n42 VO_ota.n40 4.5005
R395 VO_ota.n77 VO_ota.n39 4.5005
R396 VO_ota.n82 VO_ota.n81 4.5005
R397 VO_ota.n84 VO_ota.n83 4.5005
R398 VO_ota.n37 VO_ota.n36 4.5005
R399 VO_ota.n90 VO_ota.n89 4.5005
R400 VO_ota.n96 VO_ota.n95 4.5005
R401 VO_ota.n282 VO_ota.n278 4.5005
R402 VO_ota.n302 VO_ota.n301 4.5005
R403 VO_ota.n300 VO_ota.n299 4.5005
R404 VO_ota.n284 VO_ota.n283 4.5005
R405 VO_ota.n294 VO_ota.n293 4.5005
R406 VO_ota.n292 VO_ota.n291 4.5005
R407 VO_ota.n287 VO_ota.n286 4.5005
R408 VO_ota.n2 VO_ota.n0 4.5005
R409 VO_ota.n320 VO_ota.n319 4.5005
R410 VO_ota.n318 VO_ota.n317 4.5005
R411 VO_ota.n4 VO_ota.n3 4.5005
R412 VO_ota.n312 VO_ota.n311 4.5005
R413 VO_ota.n310 VO_ota.n309 4.5005
R414 VO_ota.n9 VO_ota.n8 4.5005
R415 VO_ota.n16 VO_ota.n15 4.5005
R416 VO_ota.n267 VO_ota.n266 4.5005
R417 VO_ota.n265 VO_ota.n13 4.5005
R418 VO_ota.n18 VO_ota.n17 4.5005
R419 VO_ota.n264 VO_ota.n263 4.1917
R420 VO_ota.n103 VO_ota.n102 3.4105
R421 VO_ota.n186 VO_ota.n185 3.4105
R422 VO_ota.n263 VO_ota.n262 3.4105
R423 VO_ota.n103 VO_ota.t6 3.10481
R424 VO_ota.n101 VO_ota.n97 2.4026
R425 VO_ota.n255 VO_ota.n254 2.376
R426 VO_ota.n172 VO_ota.n171 2.376
R427 VO_ota.n91 VO_ota.n90 2.376
R428 VO_ota.n282 VO_ota.n281 2.376
R429 VO_ota.n186 VO_ota.n103 0.778564
R430 VO_ota.n263 VO_ota.n186 0.77543
R431 VO_ota.n262 VO_ota.n260 0.67278
R432 VO_ota.n185 VO_ota.n177 0.67278
R433 VO_ota.n102 VO_ota.n96 0.67278
R434 VO_ota.n265 VO_ota.n264 0.67278
R435 VO_ota.n185 VO_ota.n184 0.539056
R436 VO_ota.n102 VO_ota.n101 0.539056
R437 VO_ota.n264 VO_ota.n23 0.539056
R438 VO_ota.n236 VO_ota.n204 0.1255
R439 VO_ota.n259 VO_ota.n188 0.1255
R440 VO_ota.n254 VO_ota.n199 0.1255
R441 VO_ota.n247 VO_ota.n199 0.1255
R442 VO_ota.n247 VO_ota.n246 0.1255
R443 VO_ota.n246 VO_ota.n202 0.1255
R444 VO_ota.n205 VO_ota.n202 0.1255
R445 VO_ota.n235 VO_ota.n205 0.1255
R446 VO_ota.n235 VO_ota.n234 0.1255
R447 VO_ota.n234 VO_ota.n233 0.1255
R448 VO_ota.n233 VO_ota.n206 0.1255
R449 VO_ota.n209 VO_ota.n206 0.1255
R450 VO_ota.n222 VO_ota.n209 0.1255
R451 VO_ota.n222 VO_ota.n221 0.1255
R452 VO_ota.n221 VO_ota.n210 0.1255
R453 VO_ota.n212 VO_ota.n210 0.1255
R454 VO_ota.n212 VO_ota.n187 0.1255
R455 VO_ota.n260 VO_ota.n187 0.1255
R456 VO_ota.n153 VO_ota.n121 0.1255
R457 VO_ota.n176 VO_ota.n105 0.1255
R458 VO_ota.n171 VO_ota.n116 0.1255
R459 VO_ota.n164 VO_ota.n116 0.1255
R460 VO_ota.n164 VO_ota.n163 0.1255
R461 VO_ota.n163 VO_ota.n119 0.1255
R462 VO_ota.n122 VO_ota.n119 0.1255
R463 VO_ota.n152 VO_ota.n122 0.1255
R464 VO_ota.n152 VO_ota.n151 0.1255
R465 VO_ota.n151 VO_ota.n150 0.1255
R466 VO_ota.n150 VO_ota.n123 0.1255
R467 VO_ota.n126 VO_ota.n123 0.1255
R468 VO_ota.n139 VO_ota.n126 0.1255
R469 VO_ota.n139 VO_ota.n138 0.1255
R470 VO_ota.n138 VO_ota.n127 0.1255
R471 VO_ota.n129 VO_ota.n127 0.1255
R472 VO_ota.n129 VO_ota.n104 0.1255
R473 VO_ota.n177 VO_ota.n104 0.1255
R474 VO_ota.n184 VO_ota.n178 0.1255
R475 VO_ota.n73 VO_ota.n41 0.1255
R476 VO_ota.n69 VO_ota.n41 0.1255
R477 VO_ota.n95 VO_ota.n25 0.1255
R478 VO_ota.n90 VO_ota.n36 0.1255
R479 VO_ota.n83 VO_ota.n36 0.1255
R480 VO_ota.n83 VO_ota.n82 0.1255
R481 VO_ota.n82 VO_ota.n39 0.1255
R482 VO_ota.n42 VO_ota.n39 0.1255
R483 VO_ota.n72 VO_ota.n42 0.1255
R484 VO_ota.n72 VO_ota.n71 0.1255
R485 VO_ota.n71 VO_ota.n70 0.1255
R486 VO_ota.n70 VO_ota.n43 0.1255
R487 VO_ota.n46 VO_ota.n43 0.1255
R488 VO_ota.n59 VO_ota.n46 0.1255
R489 VO_ota.n59 VO_ota.n58 0.1255
R490 VO_ota.n58 VO_ota.n47 0.1255
R491 VO_ota.n49 VO_ota.n47 0.1255
R492 VO_ota.n49 VO_ota.n24 0.1255
R493 VO_ota.n96 VO_ota.n24 0.1255
R494 VO_ota.n287 VO_ota.n0 0.1255
R495 VO_ota.n267 VO_ota.n13 0.1255
R496 VO_ota.n301 VO_ota.n282 0.1255
R497 VO_ota.n301 VO_ota.n300 0.1255
R498 VO_ota.n300 VO_ota.n283 0.1255
R499 VO_ota.n293 VO_ota.n283 0.1255
R500 VO_ota.n293 VO_ota.n292 0.1255
R501 VO_ota.n292 VO_ota.n286 0.1255
R502 VO_ota.n286 VO_ota.n2 0.1255
R503 VO_ota.n319 VO_ota.n2 0.1255
R504 VO_ota.n319 VO_ota.n318 0.1255
R505 VO_ota.n318 VO_ota.n3 0.1255
R506 VO_ota.n311 VO_ota.n3 0.1255
R507 VO_ota.n311 VO_ota.n310 0.1255
R508 VO_ota.n310 VO_ota.n8 0.1255
R509 VO_ota.n16 VO_ota.n8 0.1255
R510 VO_ota.n266 VO_ota.n16 0.1255
R511 VO_ota.n266 VO_ota.n265 0.1255
R512 VO_ota.n23 VO_ota.n17 0.1255
R513 VO_ota.n253 VO_ota.n198 0.109875
R514 VO_ota.n237 VO_ota.n203 0.109875
R515 VO_ota.n231 VO_ota.n228 0.109875
R516 VO_ota.n213 VO_ota.n211 0.109875
R517 VO_ota.n170 VO_ota.n115 0.109875
R518 VO_ota.n154 VO_ota.n120 0.109875
R519 VO_ota.n148 VO_ota.n145 0.109875
R520 VO_ota.n130 VO_ota.n128 0.109875
R521 VO_ota.n89 VO_ota.n35 0.109875
R522 VO_ota VO_ota.n40 0.109875
R523 VO_ota.n68 VO_ota.n65 0.109875
R524 VO_ota.n50 VO_ota.n48 0.109875
R525 VO_ota.n280 VO_ota.n278 0.109875
R526 VO_ota.n291 VO_ota.n290 0.109875
R527 VO_ota.n317 VO_ota.n1 0.109875
R528 VO_ota.n268 VO_ota.n15 0.109875
R529 VO_ota VO_ota.n204 0.107922
R530 VO_ota VO_ota.n0 0.107922
R531 VO_ota.n252 VO_ota.n200 0.09425
R532 VO_ota.n241 VO_ota.n240 0.09425
R533 VO_ota.n227 VO_ota.n207 0.09425
R534 VO_ota.n216 VO_ota.n215 0.09425
R535 VO_ota.n169 VO_ota.n117 0.09425
R536 VO_ota.n158 VO_ota.n157 0.09425
R537 VO_ota.n144 VO_ota.n124 0.09425
R538 VO_ota.n133 VO_ota.n132 0.09425
R539 VO_ota.n88 VO_ota.n37 0.09425
R540 VO_ota.n77 VO_ota.n76 0.09425
R541 VO_ota.n64 VO_ota.n44 0.09425
R542 VO_ota.n53 VO_ota.n52 0.09425
R543 VO_ota.n303 VO_ota.n302 0.09425
R544 VO_ota.n294 VO_ota.n285 0.09425
R545 VO_ota.n316 VO_ota.n4 0.09425
R546 VO_ota.n14 VO_ota.n9 0.09425
R547 VO_ota.n249 VO_ota.n248 0.078625
R548 VO_ota.n245 VO_ota.n244 0.078625
R549 VO_ota.n224 VO_ota.n223 0.078625
R550 VO_ota.n220 VO_ota.n219 0.078625
R551 VO_ota.n166 VO_ota.n165 0.078625
R552 VO_ota.n162 VO_ota.n161 0.078625
R553 VO_ota.n141 VO_ota.n140 0.078625
R554 VO_ota.n137 VO_ota.n136 0.078625
R555 VO_ota.n85 VO_ota.n84 0.078625
R556 VO_ota.n81 VO_ota.n80 0.078625
R557 VO_ota.n61 VO_ota.n60 0.078625
R558 VO_ota.n57 VO_ota.n56 0.078625
R559 VO_ota.n299 VO_ota.n279 0.078625
R560 VO_ota.n295 VO_ota.n284 0.078625
R561 VO_ota.n313 VO_ota.n312 0.078625
R562 VO_ota.n309 VO_ota.n308 0.078625
R563 VO_ota.n255 VO_ota.n198 0.0774358
R564 VO_ota.n172 VO_ota.n115 0.0774358
R565 VO_ota.n91 VO_ota.n35 0.0774358
R566 VO_ota.n281 VO_ota.n280 0.0774358
R567 VO_ota VO_ota.n121 0.0766719
R568 VO_ota VO_ota.n97 0.0723155
R569 VO_ota.n183 VO_ota.n179 0.0708125
R570 VO_ota.n22 VO_ota.n18 0.0708125
R571 VO_ota.n248 VO_ota.n201 0.063
R572 VO_ota.n245 VO_ota.n201 0.063
R573 VO_ota.n223 VO_ota.n208 0.063
R574 VO_ota.n220 VO_ota.n208 0.063
R575 VO_ota.n165 VO_ota.n118 0.063
R576 VO_ota.n162 VO_ota.n118 0.063
R577 VO_ota.n140 VO_ota.n125 0.063
R578 VO_ota.n137 VO_ota.n125 0.063
R579 VO_ota.n84 VO_ota.n38 0.063
R580 VO_ota.n81 VO_ota.n38 0.063
R581 VO_ota.n60 VO_ota.n45 0.063
R582 VO_ota.n57 VO_ota.n45 0.063
R583 VO_ota.n299 VO_ota.n298 0.063
R584 VO_ota.n298 VO_ota.n284 0.063
R585 VO_ota.n312 VO_ota.n7 0.063
R586 VO_ota.n309 VO_ota.n7 0.063
R587 VO_ota.n149 VO_ota 0.0493281
R588 VO_ota.n249 VO_ota.n200 0.047375
R589 VO_ota.n244 VO_ota.n241 0.047375
R590 VO_ota.n224 VO_ota.n207 0.047375
R591 VO_ota.n219 VO_ota.n216 0.047375
R592 VO_ota.n166 VO_ota.n117 0.047375
R593 VO_ota.n161 VO_ota.n158 0.047375
R594 VO_ota.n141 VO_ota.n124 0.047375
R595 VO_ota.n136 VO_ota.n133 0.047375
R596 VO_ota.n85 VO_ota.n37 0.047375
R597 VO_ota.n80 VO_ota.n77 0.047375
R598 VO_ota.n61 VO_ota.n44 0.047375
R599 VO_ota.n56 VO_ota.n53 0.047375
R600 VO_ota.n302 VO_ota.n279 0.047375
R601 VO_ota.n295 VO_ota.n294 0.047375
R602 VO_ota.n313 VO_ota.n4 0.047375
R603 VO_ota.n308 VO_ota.n9 0.047375
R604 VO_ota VO_ota.n179 0.0376094
R605 VO_ota VO_ota.n18 0.0376094
R606 VO_ota.n180 VO_ota 0.0337031
R607 VO_ota.n100 VO_ota 0.0337031
R608 VO_ota.n19 VO_ota 0.0337031
R609 VO_ota.n253 VO_ota.n252 0.03175
R610 VO_ota.n240 VO_ota.n203 0.03175
R611 VO_ota.n228 VO_ota.n227 0.03175
R612 VO_ota.n215 VO_ota.n213 0.03175
R613 VO_ota.n170 VO_ota.n169 0.03175
R614 VO_ota.n157 VO_ota.n120 0.03175
R615 VO_ota.n145 VO_ota.n144 0.03175
R616 VO_ota.n132 VO_ota.n130 0.03175
R617 VO_ota.n89 VO_ota.n88 0.03175
R618 VO_ota.n76 VO_ota.n40 0.03175
R619 VO_ota.n65 VO_ota.n64 0.03175
R620 VO_ota.n52 VO_ota.n50 0.03175
R621 VO_ota.n303 VO_ota.n278 0.03175
R622 VO_ota.n291 VO_ota.n285 0.03175
R623 VO_ota.n317 VO_ota.n316 0.03175
R624 VO_ota.n15 VO_ota.n14 0.03175
R625 VO_ota.n232 VO_ota 0.0180781
R626 VO_ota VO_ota.n320 0.0180781
R627 VO_ota.n237 VO_ota.n236 0.016125
R628 VO_ota.n232 VO_ota.n231 0.016125
R629 VO_ota.n211 VO_ota.n188 0.016125
R630 VO_ota.n154 VO_ota.n153 0.016125
R631 VO_ota.n149 VO_ota.n148 0.016125
R632 VO_ota.n128 VO_ota.n105 0.016125
R633 VO_ota VO_ota.n73 0.016125
R634 VO_ota.n69 VO_ota.n68 0.016125
R635 VO_ota.n48 VO_ota.n25 0.016125
R636 VO_ota.n290 VO_ota.n287 0.016125
R637 VO_ota.n320 VO_ota.n1 0.016125
R638 VO_ota.n268 VO_ota.n267 0.016125
R639 VDD.n2696 VDD.n2695 27511.5
R640 VDD.n2697 VDD.n754 20218.8
R641 VDD.t32 VDD.n2461 11930.5
R642 VDD.n1030 VDD.n1027 10404.7
R643 VDD.n2462 VDD.t32 2331.82
R644 VDD.n2047 VDD.n2046 585
R645 VDD.n1949 VDD.n1948 585
R646 VDD.n1680 VDD.n1679 585
R647 VDD.n1538 VDD.n1148 585
R648 VDD.n2155 VDD.n2154 585
R649 VDD.n2421 VDD.n1063 585
R650 VDD.n1456 VDD.n1455 585
R651 VDD.n1309 VDD.n1308 585
R652 VDD.n2788 VDD.n151 585
R653 VDD.n666 VDD.n665 585
R654 VDD.n2928 VDD.n2927 585
R655 VDD.n2977 VDD.n2976 585
R656 VDD.n2697 VDD.n2696 475
R657 VDD.n2462 VDD.n1030 345.455
R658 VDD.n2047 VDD.n1990 285.877
R659 VDD.n2047 VDD.n1991 285.877
R660 VDD.n2047 VDD.n1992 285.877
R661 VDD.n2047 VDD.n1993 285.877
R662 VDD.n2047 VDD.n1974 285.877
R663 VDD.n2047 VDD.n1975 285.877
R664 VDD.n2047 VDD.n1998 285.877
R665 VDD.n2048 VDD.n2047 285.877
R666 VDD.n1949 VDD.n1900 285.877
R667 VDD.n1949 VDD.n1899 285.877
R668 VDD.n1949 VDD.n1898 285.877
R669 VDD.n1949 VDD.n1897 285.877
R670 VDD.n1949 VDD.n1105 285.877
R671 VDD.n1949 VDD.n1106 285.877
R672 VDD.n1949 VDD.n1896 285.877
R673 VDD.n1950 VDD.n1949 285.877
R674 VDD.n1680 VDD.n1594 285.877
R675 VDD.n1680 VDD.n1593 285.877
R676 VDD.n1680 VDD.n1592 285.877
R677 VDD.n1680 VDD.n1591 285.877
R678 VDD.n1680 VDD.n1590 285.877
R679 VDD.n1680 VDD.n1589 285.877
R680 VDD.n1680 VDD.n1588 285.877
R681 VDD.n1681 VDD.n1680 285.877
R682 VDD.n1538 VDD.n1537 285.877
R683 VDD.n1539 VDD.n1538 285.877
R684 VDD.n1538 VDD.n1535 285.877
R685 VDD.n1538 VDD.n1162 285.877
R686 VDD.n1538 VDD.n1161 285.877
R687 VDD.n1538 VDD.n1160 285.877
R688 VDD.n1538 VDD.n1159 285.877
R689 VDD.n1538 VDD.n1158 285.877
R690 VDD.n2155 VDD.n2089 285.877
R691 VDD.n2155 VDD.n2090 285.877
R692 VDD.n2155 VDD.n2091 285.877
R693 VDD.n2155 VDD.n2092 285.877
R694 VDD.n2155 VDD.n2072 285.877
R695 VDD.n2155 VDD.n2073 285.877
R696 VDD.n2155 VDD.n2097 285.877
R697 VDD.n2156 VDD.n2155 285.877
R698 VDD.n2421 VDD.n1074 285.877
R699 VDD.n2422 VDD.n2421 285.877
R700 VDD.n2421 VDD.n1075 285.877
R701 VDD.n2421 VDD.n1076 285.877
R702 VDD.n2421 VDD.n1077 285.877
R703 VDD.n2421 VDD.n1078 285.877
R704 VDD.n2421 VDD.n1079 285.877
R705 VDD.n2421 VDD.n2420 285.877
R706 VDD.n1456 VDD.n1400 285.877
R707 VDD.n1456 VDD.n1401 285.877
R708 VDD.n1456 VDD.n1402 285.877
R709 VDD.n1456 VDD.n1403 285.877
R710 VDD.n1456 VDD.n1333 285.877
R711 VDD.n1456 VDD.n1334 285.877
R712 VDD.n1456 VDD.n1408 285.877
R713 VDD.n1457 VDD.n1456 285.877
R714 VDD.n1309 VDD.n1252 285.877
R715 VDD.n1309 VDD.n1253 285.877
R716 VDD.n1309 VDD.n1254 285.877
R717 VDD.n1309 VDD.n1255 285.877
R718 VDD.n1309 VDD.n1179 285.877
R719 VDD.n1309 VDD.n1180 285.877
R720 VDD.n1309 VDD.n1260 285.877
R721 VDD.n1310 VDD.n1309 285.877
R722 VDD.n2788 VDD.n2787 285.877
R723 VDD.n2789 VDD.n2788 285.877
R724 VDD.n2788 VDD.n2785 285.877
R725 VDD.n2788 VDD.n165 285.877
R726 VDD.n2788 VDD.n164 285.877
R727 VDD.n2788 VDD.n163 285.877
R728 VDD.n2788 VDD.n162 285.877
R729 VDD.n2788 VDD.n161 285.877
R730 VDD.n666 VDD.n579 285.877
R731 VDD.n666 VDD.n578 285.877
R732 VDD.n666 VDD.n577 285.877
R733 VDD.n666 VDD.n576 285.877
R734 VDD.n666 VDD.n575 285.877
R735 VDD.n666 VDD.n574 285.877
R736 VDD.n666 VDD.n573 285.877
R737 VDD.n667 VDD.n666 285.877
R738 VDD.n2928 VDD.n57 285.877
R739 VDD.n2928 VDD.n56 285.877
R740 VDD.n2928 VDD.n55 285.877
R741 VDD.n2928 VDD.n54 285.877
R742 VDD.n2928 VDD.n35 285.877
R743 VDD.n2928 VDD.n36 285.877
R744 VDD.n2928 VDD.n53 285.877
R745 VDD.n2929 VDD.n2928 285.877
R746 VDD.n2977 VDD.n4 285.877
R747 VDD.n2977 VDD.n5 285.877
R748 VDD.n2977 VDD.n6 285.877
R749 VDD.n2978 VDD.n2977 285.877
R750 VDD.n2977 VDD.n7 285.877
R751 VDD.n2977 VDD.n8 285.877
R752 VDD.n2977 VDD.n9 285.877
R753 VDD.n2977 VDD.n10 285.877
R754 VDD.n2322 VDD.n2321 185.883
R755 VDD.n2325 VDD.n2324 185.883
R756 VDD.n2347 VDD.n2346 185
R757 VDD.n2290 VDD.n2288 185
R758 VDD.n2353 VDD.n2352 185
R759 VDD.n2355 VDD.n2287 185
R760 VDD.n2357 VDD.n2356 185
R761 VDD.n2282 VDD.n2280 185
R762 VDD.n2363 VDD.n2362 185
R763 VDD.n2365 VDD.n2279 185
R764 VDD.n2367 VDD.n2366 185
R765 VDD.n2275 VDD.n2273 185
R766 VDD.n2373 VDD.n2372 185
R767 VDD.n2375 VDD.n2271 185
R768 VDD.n2377 VDD.n2376 185
R769 VDD.n2268 VDD.n2266 185
R770 VDD.n2383 VDD.n2382 185
R771 VDD.n2385 VDD.n2265 185
R772 VDD.n2387 VDD.n2386 185
R773 VDD.n2260 VDD.n2258 185
R774 VDD.n2393 VDD.n2392 185
R775 VDD.n2395 VDD.n2257 185
R776 VDD.n2397 VDD.n2396 185
R777 VDD.n2251 VDD.n2250 185
R778 VDD.n2403 VDD.n2402 185
R779 VDD.n2406 VDD.n2405 185
R780 VDD.n2326 VDD.n2322 185
R781 VDD.n2314 VDD.n2313 185
R782 VDD.n2327 VDD.n2313 185
R783 VDD.n2318 VDD.n2312 185
R784 VDD.n2328 VDD.n2312 185
R785 VDD.n2316 VDD.n2298 185
R786 VDD.n2301 VDD.n2298 185
R787 VDD.n2339 VDD.n2338 185
R788 VDD.n2338 VDD.n2337 185
R789 VDD.n2297 VDD.n2294 185
R790 VDD.n2300 VDD.n2297 185
R791 VDD.n2344 VDD.n2242 185
R792 VDD.n2299 VDD.n2242 185
R793 VDD.n2411 VDD.n2243 185
R794 VDD.n2411 VDD.n2410 185
R795 VDD.n2413 VDD.n2412 185
R796 VDD.n2412 VDD.n1053 185
R797 VDD.n2240 VDD.n1052 185
R798 VDD.n2441 VDD.n1052 185
R799 VDD.n2238 VDD.n1051 185
R800 VDD.n2442 VDD.n1051 185
R801 VDD.n2230 VDD.n1050 185
R802 VDD.n2443 VDD.n1050 185
R803 VDD.n2233 VDD.n1039 185
R804 VDD.n1041 VDD.n1039 185
R805 VDD.n2453 VDD.n1040 185
R806 VDD.n2453 VDD.n2452 185
R807 VDD.n2455 VDD.n2454 185
R808 VDD.n2454 VDD.n1032 185
R809 VDD.n1035 VDD.n1033 185
R810 VDD.n1033 VDD.n1031 185
R811 VDD.n2103 VDD.n2102 185
R812 VDD.n2102 VDD.n1031 185
R813 VDD.n2104 VDD.n1042 185
R814 VDD.n1042 VDD.n1032 185
R815 VDD.n2451 VDD.n2450 185
R816 VDD.n2452 VDD.n2451 185
R817 VDD.n1045 VDD.n1043 185
R818 VDD.n1043 VDD.n1041 185
R819 VDD.n2445 VDD.n2444 185
R820 VDD.n2444 VDD.n2443 185
R821 VDD.n1055 VDD.n1049 185
R822 VDD.n2442 VDD.n1049 185
R823 VDD.n2440 VDD.n2439 185
R824 VDD.n2441 VDD.n2440 185
R825 VDD.n1057 VDD.n1054 185
R826 VDD.n1054 VDD.n1053 185
R827 VDD.n2409 VDD.n2408 185
R828 VDD.n2410 VDD.n2409 185
R829 VDD.n2407 VDD.n2245 185
R830 VDD.n2299 VDD.n2245 185
R831 VDD.n2304 VDD.n2302 185
R832 VDD.n2302 VDD.n2300 185
R833 VDD.n2336 VDD.n2335 185
R834 VDD.n2337 VDD.n2336 185
R835 VDD.n2306 VDD.n2303 185
R836 VDD.n2303 VDD.n2301 185
R837 VDD.n2330 VDD.n2329 185
R838 VDD.n2329 VDD.n2328 185
R839 VDD.n2323 VDD.n2311 185
R840 VDD.n2327 VDD.n2311 185
R841 VDD.n2326 VDD.n2325 185
R842 VDD.n2461 VDD.n2460 185
R843 VDD.n1027 VDD.n1026 185
R844 VDD.n1034 VDD.n1029 185
R845 VDD.n2463 VDD.n1029 185
R846 VDD.n1855 VDD.n1738 185
R847 VDD.n1745 VDD.n1738 185
R848 VDD.n1794 VDD.n1793 185
R849 VDD.n1785 VDD.n1784 185
R850 VDD.n1800 VDD.n1799 185
R851 VDD.n1802 VDD.n1782 185
R852 VDD.n1804 VDD.n1803 185
R853 VDD.n1779 VDD.n1777 185
R854 VDD.n1810 VDD.n1809 185
R855 VDD.n1812 VDD.n1776 185
R856 VDD.n1814 VDD.n1813 185
R857 VDD.n1771 VDD.n1769 185
R858 VDD.n1820 VDD.n1819 185
R859 VDD.n1822 VDD.n1768 185
R860 VDD.n1824 VDD.n1823 185
R861 VDD.n1763 VDD.n1761 185
R862 VDD.n1830 VDD.n1829 185
R863 VDD.n1832 VDD.n1760 185
R864 VDD.n1834 VDD.n1833 185
R865 VDD.n1754 VDD.n1752 185
R866 VDD.n1840 VDD.n1839 185
R867 VDD.n1842 VDD.n1751 185
R868 VDD.n1844 VDD.n1843 185
R869 VDD.n1845 VDD.n1747 185
R870 VDD.n1847 VDD.n1846 185
R871 VDD.n1850 VDD.n1849 185
R872 VDD.n1744 VDD.n1741 185
R873 VDD.n1746 VDD.n1744 185
R874 VDD.n1792 VDD.n1791 185
R875 VDD.n1792 VDD.n1028 185
R876 VDD.n1789 VDD.n1011 185
R877 VDD.n1015 VDD.n1011 185
R878 VDD.n2474 VDD.n2473 185
R879 VDD.n2473 VDD.n2472 185
R880 VDD.n1003 VDD.n1001 185
R881 VDD.n1012 VDD.n1001 185
R882 VDD.n2480 VDD.n2479 185
R883 VDD.n2481 VDD.n2480 185
R884 VDD.n1005 VDD.n1000 185
R885 VDD.n1000 VDD.n997 185
R886 VDD.n1004 VDD.n980 185
R887 VDD.n984 VDD.n980 185
R888 VDD.n2494 VDD.n2493 185
R889 VDD.n2493 VDD.n2492 185
R890 VDD.n976 VDD.n972 185
R891 VDD.n981 VDD.n972 185
R892 VDD.n2500 VDD.n2499 185
R893 VDD.n2501 VDD.n2500 185
R894 VDD.n974 VDD.n971 185
R895 VDD.n1727 VDD.n971 185
R896 VDD.n952 VDD.n951 185
R897 VDD.n955 VDD.n952 185
R898 VDD.n2514 VDD.n2513 185
R899 VDD.n2513 VDD.n2512 185
R900 VDD.n944 VDD.n942 185
R901 VDD.n1722 VDD.n942 185
R902 VDD.n2520 VDD.n2519 185
R903 VDD.n2521 VDD.n2520 185
R904 VDD.n946 VDD.n941 185
R905 VDD.n941 VDD.n939 185
R906 VDD.n945 VDD.n925 185
R907 VDD.n929 VDD.n925 185
R908 VDD.n2534 VDD.n2533 185
R909 VDD.n2533 VDD.n2532 185
R910 VDD.n921 VDD.n919 185
R911 VDD.n926 VDD.n919 185
R912 VDD.n2540 VDD.n2539 185
R913 VDD.n2541 VDD.n2540 185
R914 VDD.n1694 VDD.n918 185
R915 VDD.n918 VDD.n915 185
R916 VDD.n1699 VDD.n1698 185
R917 VDD.n1700 VDD.n1699 185
R918 VDD.n1692 VDD.n893 185
R919 VDD.n897 VDD.n893 185
R920 VDD.n2557 VDD.n2556 185
R921 VDD.n2556 VDD.n2555 185
R922 VDD.n885 VDD.n883 185
R923 VDD.n894 VDD.n883 185
R924 VDD.n2563 VDD.n2562 185
R925 VDD.n2564 VDD.n2563 185
R926 VDD.n887 VDD.n882 185
R927 VDD.n882 VDD.n879 185
R928 VDD.n886 VDD.n868 185
R929 VDD.n1570 VDD.n868 185
R930 VDD.n2577 VDD.n2576 185
R931 VDD.n2576 VDD.n2575 185
R932 VDD.n867 VDD.n865 185
R933 VDD.n1141 VDD.n867 185
R934 VDD.n858 VDD.n856 185
R935 VDD.n1140 VDD.n856 185
R936 VDD.n2583 VDD.n2582 185
R937 VDD.n2584 VDD.n2583 185
R938 VDD.n860 VDD.n855 185
R939 VDD.n1379 VDD.n855 185
R940 VDD.n859 VDD.n840 185
R941 VDD.n843 VDD.n840 185
R942 VDD.n2597 VDD.n2596 185
R943 VDD.n2596 VDD.n2595 185
R944 VDD.n836 VDD.n834 185
R945 VDD.n1389 VDD.n834 185
R946 VDD.n2603 VDD.n2602 185
R947 VDD.n2604 VDD.n2603 185
R948 VDD.n1361 VDD.n833 185
R949 VDD.n833 VDD.n831 185
R950 VDD.n1369 VDD.n1368 185
R951 VDD.n1370 VDD.n1369 185
R952 VDD.n1362 VDD.n807 185
R953 VDD.n809 VDD.n807 185
R954 VDD.n2619 VDD.n806 185
R955 VDD.n2619 VDD.n2618 185
R956 VDD.n818 VDD.n817 185
R957 VDD.n817 VDD.n757 185
R958 VDD.n819 VDD.n810 185
R959 VDD.n810 VDD.n778 185
R960 VDD.n2616 VDD.n2615 185
R961 VDD.n2617 VDD.n2616 185
R962 VDD.n813 VDD.n811 185
R963 VDD.n1359 VDD.n811 185
R964 VDD.n829 VDD.n827 185
R965 VDD.n1371 VDD.n829 185
R966 VDD.n2607 VDD.n2606 185
R967 VDD.n2606 VDD.n2605 185
R968 VDD.n830 VDD.n828 185
R969 VDD.n1390 VDD.n830 185
R970 VDD.n846 VDD.n844 185
R971 VDD.n844 VDD.n841 185
R972 VDD.n2593 VDD.n2592 185
R973 VDD.n2594 VDD.n2593 185
R974 VDD.n848 VDD.n845 185
R975 VDD.n1380 VDD.n845 185
R976 VDD.n2587 VDD.n2586 185
R977 VDD.n2586 VDD.n2585 185
R978 VDD.n1142 VDD.n852 185
R979 VDD.n854 VDD.n852 185
R980 VDD.n1557 VDD.n1556 185
R981 VDD.n1558 VDD.n1557 185
R982 VDD.n1144 VDD.n871 185
R983 VDD.n871 VDD.n869 185
R984 VDD.n2573 VDD.n2572 185
R985 VDD.n2574 VDD.n2573 185
R986 VDD.n874 VDD.n872 185
R987 VDD.n1571 VDD.n872 185
R988 VDD.n2567 VDD.n2566 185
R989 VDD.n2566 VDD.n2565 185
R990 VDD.n902 VDD.n878 185
R991 VDD.n881 VDD.n878 185
R992 VDD.n903 VDD.n898 185
R993 VDD.n898 VDD.n895 185
R994 VDD.n2553 VDD.n2552 185
R995 VDD.n2554 VDD.n2553 185
R996 VDD.n901 VDD.n899 185
R997 VDD.n1691 VDD.n899 185
R998 VDD.n913 VDD.n911 185
R999 VDD.n1701 VDD.n913 185
R1000 VDD.n2544 VDD.n2543 185
R1001 VDD.n2543 VDD.n2542 185
R1002 VDD.n932 VDD.n914 185
R1003 VDD.n917 VDD.n914 185
R1004 VDD.n933 VDD.n930 185
R1005 VDD.n930 VDD.n927 185
R1006 VDD.n2530 VDD.n2529 185
R1007 VDD.n2531 VDD.n2530 185
R1008 VDD.n934 VDD.n931 185
R1009 VDD.n1714 VDD.n931 185
R1010 VDD.n2524 VDD.n2523 185
R1011 VDD.n2523 VDD.n2522 185
R1012 VDD.n960 VDD.n938 185
R1013 VDD.n1723 VDD.n938 185
R1014 VDD.n961 VDD.n956 185
R1015 VDD.n956 VDD.n953 185
R1016 VDD.n2510 VDD.n2509 185
R1017 VDD.n2511 VDD.n2510 185
R1018 VDD.n959 VDD.n957 185
R1019 VDD.n1728 VDD.n957 185
R1020 VDD.n2504 VDD.n2503 185
R1021 VDD.n2503 VDD.n2502 185
R1022 VDD.n989 VDD.n968 185
R1023 VDD.n970 VDD.n968 185
R1024 VDD.n990 VDD.n985 185
R1025 VDD.n985 VDD.n982 185
R1026 VDD.n2490 VDD.n2489 185
R1027 VDD.n2491 VDD.n2490 185
R1028 VDD.n988 VDD.n986 185
R1029 VDD.n1867 VDD.n986 185
R1030 VDD.n2484 VDD.n2483 185
R1031 VDD.n2483 VDD.n2482 185
R1032 VDD.n1020 VDD.n996 185
R1033 VDD.n999 VDD.n996 185
R1034 VDD.n1021 VDD.n1016 185
R1035 VDD.n1016 VDD.n1013 185
R1036 VDD.n2470 VDD.n2469 185
R1037 VDD.n2471 VDD.n2470 185
R1038 VDD.n1019 VDD.n1017 185
R1039 VDD.n1745 VDD.n1017 185
R1040 VDD.n2465 VDD.n2464 185
R1041 VDD.n2464 VDD.n2463 185
R1042 VDD.n815 VDD.n754 185
R1043 VDD.n300 VDD.n275 185
R1044 VDD.n276 VDD.n275 185
R1045 VDD.n447 VDD.n446 185
R1046 VDD.n446 VDD.n445 185
R1047 VDD.n448 VDD.n270 185
R1048 VDD.n270 VDD.n268 185
R1049 VDD.n456 VDD.n455 185
R1050 VDD.n457 VDD.n456 185
R1051 VDD.n272 VDD.n261 185
R1052 VDD.n269 VDD.n261 185
R1053 VDD.n470 VDD.n469 185
R1054 VDD.n469 VDD.n468 185
R1055 VDD.n471 VDD.n256 185
R1056 VDD.n256 VDD.n255 185
R1057 VDD.n478 VDD.n477 185
R1058 VDD.n479 VDD.n478 185
R1059 VDD.n258 VDD.n247 185
R1060 VDD.n248 VDD.n247 185
R1061 VDD.n494 VDD.n493 185
R1062 VDD.n493 VDD.n492 185
R1063 VDD.n495 VDD.n242 185
R1064 VDD.n242 VDD.n241 185
R1065 VDD.n502 VDD.n501 185
R1066 VDD.n503 VDD.n502 185
R1067 VDD.n244 VDD.n231 185
R1068 VDD.n233 VDD.n231 185
R1069 VDD.n525 VDD.n524 185
R1070 VDD.n524 VDD.n523 185
R1071 VDD.n232 VDD.n228 185
R1072 VDD.n522 VDD.n232 185
R1073 VDD.n530 VDD.n227 185
R1074 VDD.n227 VDD.n226 185
R1075 VDD.n532 VDD.n531 185
R1076 VDD.n533 VDD.n532 185
R1077 VDD.n65 VDD.n63 185
R1078 VDD.n67 VDD.n65 185
R1079 VDD.n2877 VDD.n2876 185
R1080 VDD.n2876 VDD.n2875 185
R1081 VDD.n73 VDD.n66 185
R1082 VDD.n2874 VDD.n66 185
R1083 VDD.n2872 VDD.n2871 185
R1084 VDD.n2873 VDD.n2872 185
R1085 VDD.n75 VDD.n72 185
R1086 VDD.n72 VDD.n71 185
R1087 VDD.n2866 VDD.n2865 185
R1088 VDD.n2865 VDD.n2864 185
R1089 VDD.n85 VDD.n79 185
R1090 VDD.n2863 VDD.n79 185
R1091 VDD.n2861 VDD.n2860 185
R1092 VDD.n2862 VDD.n2861 185
R1093 VDD.n87 VDD.n84 185
R1094 VDD.n84 VDD.n83 185
R1095 VDD.n2855 VDD.n2854 185
R1096 VDD.n2854 VDD.n2853 185
R1097 VDD.n97 VDD.n91 185
R1098 VDD.n2852 VDD.n91 185
R1099 VDD.n2850 VDD.n2849 185
R1100 VDD.n2851 VDD.n2850 185
R1101 VDD.n99 VDD.n96 185
R1102 VDD.n96 VDD.n95 185
R1103 VDD.n2844 VDD.n2843 185
R1104 VDD.n2843 VDD.n2842 185
R1105 VDD.n109 VDD.n103 185
R1106 VDD.n2841 VDD.n103 185
R1107 VDD.n2839 VDD.n2838 185
R1108 VDD.n2840 VDD.n2839 185
R1109 VDD.n111 VDD.n108 185
R1110 VDD.n108 VDD.n107 185
R1111 VDD.n2834 VDD.n2833 185
R1112 VDD.n2833 VDD.n2832 185
R1113 VDD.n116 VDD.n115 185
R1114 VDD.n2831 VDD.n116 185
R1115 VDD.n2829 VDD.n2828 185
R1116 VDD.n2830 VDD.n2829 185
R1117 VDD.n123 VDD.n121 185
R1118 VDD.n121 VDD.n120 185
R1119 VDD.n2823 VDD.n2822 185
R1120 VDD.n2822 VDD.n2821 185
R1121 VDD.n132 VDD.n126 185
R1122 VDD.n2820 VDD.n126 185
R1123 VDD.n2818 VDD.n2817 185
R1124 VDD.n2819 VDD.n2818 185
R1125 VDD.n134 VDD.n131 185
R1126 VDD.n131 VDD.n130 185
R1127 VDD.n2812 VDD.n2811 185
R1128 VDD.n2811 VDD.n2810 185
R1129 VDD.n144 VDD.n138 185
R1130 VDD.n2809 VDD.n138 185
R1131 VDD.n2807 VDD.n2806 185
R1132 VDD.n2808 VDD.n2807 185
R1133 VDD.n146 VDD.n143 185
R1134 VDD.n143 VDD.n142 185
R1135 VDD.n2742 VDD.n2741 185
R1136 VDD.n2743 VDD.n2742 185
R1137 VDD.n712 VDD.n710 185
R1138 VDD.n710 VDD.n709 185
R1139 VDD.n2736 VDD.n2735 185
R1140 VDD.n2735 VDD.n2734 185
R1141 VDD.n721 VDD.n715 185
R1142 VDD.n2733 VDD.n715 185
R1143 VDD.n2731 VDD.n2730 185
R1144 VDD.n2732 VDD.n2731 185
R1145 VDD.n723 VDD.n720 185
R1146 VDD.n720 VDD.n719 185
R1147 VDD.n2726 VDD.n2725 185
R1148 VDD.n2725 VDD.n2724 185
R1149 VDD.n727 VDD.n726 185
R1150 VDD.n2723 VDD.n727 185
R1151 VDD.n2721 VDD.n2720 185
R1152 VDD.n2722 VDD.n2721 185
R1153 VDD.n734 VDD.n732 185
R1154 VDD.n732 VDD.n731 185
R1155 VDD.n2715 VDD.n2714 185
R1156 VDD.n2714 VDD.n2713 185
R1157 VDD.n743 VDD.n737 185
R1158 VDD.n2712 VDD.n737 185
R1159 VDD.n2710 VDD.n2709 185
R1160 VDD.n2711 VDD.n2710 185
R1161 VDD.n745 VDD.n742 185
R1162 VDD.n742 VDD.n741 185
R1163 VDD.n1241 VDD.n1240 185
R1164 VDD.n1242 VDD.n1241 185
R1165 VDD.n753 VDD.n751 185
R1166 VDD.n755 VDD.n753 185
R1167 VDD.n2700 VDD.n2699 185
R1168 VDD.n2699 VDD.n2698 185
R1169 VDD.n388 VDD.n387 185
R1170 VDD.n389 VDD.n388 185
R1171 VDD.n302 VDD.n299 185
R1172 VDD.n382 VDD.n381 185
R1173 VDD.n380 VDD.n379 185
R1174 VDD.n372 VDD.n308 185
R1175 VDD.n374 VDD.n373 185
R1176 VDD.n370 VDD.n369 185
R1177 VDD.n368 VDD.n367 185
R1178 VDD.n360 VDD.n311 185
R1179 VDD.n362 VDD.n361 185
R1180 VDD.n358 VDD.n357 185
R1181 VDD.n356 VDD.n355 185
R1182 VDD.n354 VDD.n353 185
R1183 VDD.n352 VDD.n351 185
R1184 VDD.n344 VDD.n316 185
R1185 VDD.n346 VDD.n345 185
R1186 VDD.n342 VDD.n341 185
R1187 VDD.n340 VDD.n339 185
R1188 VDD.n332 VDD.n321 185
R1189 VDD.n334 VDD.n333 185
R1190 VDD.n330 VDD.n329 185
R1191 VDD.n328 VDD.n327 185
R1192 VDD.n284 VDD.n283 185
R1193 VDD.n391 VDD.n390 185
R1194 VDD.n390 VDD.n389 185
R1195 VDD.n285 VDD.n281 185
R1196 VDD.n286 VDD.n285 185
R1197 VDD.n301 VDD.n298 185
R1198 VDD.n298 VDD.n286 185
R1199 VDD.n2695 VDD.n2694 185
R1200 VDD.n1198 VDD.n756 185
R1201 VDD.n2698 VDD.n756 185
R1202 VDD.n1245 VDD.n1244 185
R1203 VDD.n1244 VDD.n755 185
R1204 VDD.n1243 VDD.n1197 185
R1205 VDD.n1243 VDD.n1242 185
R1206 VDD.n1238 VDD.n1237 185
R1207 VDD.n1238 VDD.n741 185
R1208 VDD.n1200 VDD.n740 185
R1209 VDD.n2711 VDD.n740 185
R1210 VDD.n1231 VDD.n739 185
R1211 VDD.n2712 VDD.n739 185
R1212 VDD.n1229 VDD.n738 185
R1213 VDD.n2713 VDD.n738 185
R1214 VDD.n1203 VDD.n1202 185
R1215 VDD.n1202 VDD.n731 185
R1216 VDD.n1224 VDD.n730 185
R1217 VDD.n2722 VDD.n730 185
R1218 VDD.n1222 VDD.n729 185
R1219 VDD.n2723 VDD.n729 185
R1220 VDD.n1221 VDD.n728 185
R1221 VDD.n2724 VDD.n728 185
R1222 VDD.n1206 VDD.n1205 185
R1223 VDD.n1205 VDD.n719 185
R1224 VDD.n1217 VDD.n718 185
R1225 VDD.n2732 VDD.n718 185
R1226 VDD.n1215 VDD.n717 185
R1227 VDD.n2733 VDD.n717 185
R1228 VDD.n1208 VDD.n716 185
R1229 VDD.n2734 VDD.n716 185
R1230 VDD.n1210 VDD.n708 185
R1231 VDD.n709 VDD.n708 185
R1232 VDD.n2745 VDD.n2744 185
R1233 VDD.n2744 VDD.n2743 185
R1234 VDD.n707 VDD.n705 185
R1235 VDD.n707 VDD.n142 185
R1236 VDD.n703 VDD.n141 185
R1237 VDD.n2808 VDD.n141 185
R1238 VDD.n202 VDD.n140 185
R1239 VDD.n2809 VDD.n140 185
R1240 VDD.n698 VDD.n139 185
R1241 VDD.n2810 VDD.n139 185
R1242 VDD.n696 VDD.n695 185
R1243 VDD.n695 VDD.n130 185
R1244 VDD.n204 VDD.n129 185
R1245 VDD.n2819 VDD.n129 185
R1246 VDD.n690 VDD.n128 185
R1247 VDD.n2820 VDD.n128 185
R1248 VDD.n688 VDD.n127 185
R1249 VDD.n2821 VDD.n127 185
R1250 VDD.n207 VDD.n206 185
R1251 VDD.n206 VDD.n120 185
R1252 VDD.n683 VDD.n119 185
R1253 VDD.n2830 VDD.n119 185
R1254 VDD.n681 VDD.n118 185
R1255 VDD.n2831 VDD.n118 185
R1256 VDD.n680 VDD.n117 185
R1257 VDD.n2832 VDD.n117 185
R1258 VDD.n210 VDD.n209 185
R1259 VDD.n209 VDD.n107 185
R1260 VDD.n676 VDD.n106 185
R1261 VDD.n2840 VDD.n106 185
R1262 VDD.n674 VDD.n105 185
R1263 VDD.n2841 VDD.n105 185
R1264 VDD.n212 VDD.n104 185
R1265 VDD.n2842 VDD.n104 185
R1266 VDD.n566 VDD.n565 185
R1267 VDD.n565 VDD.n95 185
R1268 VDD.n563 VDD.n94 185
R1269 VDD.n2851 VDD.n94 185
R1270 VDD.n215 VDD.n93 185
R1271 VDD.n2852 VDD.n93 185
R1272 VDD.n558 VDD.n92 185
R1273 VDD.n2853 VDD.n92 185
R1274 VDD.n556 VDD.n555 185
R1275 VDD.n555 VDD.n83 185
R1276 VDD.n217 VDD.n82 185
R1277 VDD.n2862 VDD.n82 185
R1278 VDD.n550 VDD.n81 185
R1279 VDD.n2863 VDD.n81 185
R1280 VDD.n548 VDD.n80 185
R1281 VDD.n2864 VDD.n80 185
R1282 VDD.n220 VDD.n219 185
R1283 VDD.n219 VDD.n71 185
R1284 VDD.n543 VDD.n70 185
R1285 VDD.n2873 VDD.n70 185
R1286 VDD.n541 VDD.n69 185
R1287 VDD.n2874 VDD.n69 185
R1288 VDD.n222 VDD.n68 185
R1289 VDD.n2875 VDD.n68 185
R1290 VDD.n536 VDD.n535 185
R1291 VDD.n535 VDD.n67 185
R1292 VDD.n534 VDD.n224 185
R1293 VDD.n534 VDD.n533 185
R1294 VDD.n236 VDD.n225 185
R1295 VDD.n226 VDD.n225 185
R1296 VDD.n521 VDD.n520 185
R1297 VDD.n522 VDD.n521 185
R1298 VDD.n507 VDD.n234 185
R1299 VDD.n523 VDD.n234 185
R1300 VDD.n506 VDD.n505 185
R1301 VDD.n505 VDD.n233 185
R1302 VDD.n504 VDD.n240 185
R1303 VDD.n504 VDD.n503 185
R1304 VDD.n251 VDD.n239 185
R1305 VDD.n241 VDD.n239 185
R1306 VDD.n491 VDD.n490 185
R1307 VDD.n492 VDD.n491 185
R1308 VDD.n482 VDD.n249 185
R1309 VDD.n249 VDD.n248 185
R1310 VDD.n481 VDD.n480 185
R1311 VDD.n480 VDD.n479 185
R1312 VDD.n264 VDD.n254 185
R1313 VDD.n255 VDD.n254 185
R1314 VDD.n467 VDD.n466 185
R1315 VDD.n468 VDD.n467 185
R1316 VDD.n460 VDD.n262 185
R1317 VDD.n269 VDD.n262 185
R1318 VDD.n459 VDD.n458 185
R1319 VDD.n458 VDD.n457 185
R1320 VDD.n279 VDD.n267 185
R1321 VDD.n268 VDD.n267 185
R1322 VDD.n444 VDD.n443 185
R1323 VDD.n445 VDD.n444 185
R1324 VDD.n280 VDD.n277 185
R1325 VDD.n277 VDD.n276 185
R1326 VDD.n1856 VDD.n1014 185
R1327 VDD.n2471 VDD.n1014 185
R1328 VDD.n1860 VDD.n1859 185
R1329 VDD.n1859 VDD.n1013 185
R1330 VDD.n1858 VDD.n1736 185
R1331 VDD.n1858 VDD.n999 185
R1332 VDD.n1865 VDD.n998 185
R1333 VDD.n2482 VDD.n998 185
R1334 VDD.n1869 VDD.n1868 185
R1335 VDD.n1868 VDD.n1867 185
R1336 VDD.n1733 VDD.n983 185
R1337 VDD.n2491 VDD.n983 185
R1338 VDD.n1875 VDD.n1874 185
R1339 VDD.n1875 VDD.n982 185
R1340 VDD.n1877 VDD.n1876 185
R1341 VDD.n1876 VDD.n970 185
R1342 VDD.n1879 VDD.n969 185
R1343 VDD.n2502 VDD.n969 185
R1344 VDD.n1730 VDD.n1729 185
R1345 VDD.n1729 VDD.n1728 185
R1346 VDD.n1884 VDD.n954 185
R1347 VDD.n2511 VDD.n954 185
R1348 VDD.n1726 VDD.n1725 185
R1349 VDD.n1725 VDD.n953 185
R1350 VDD.n1724 VDD.n1721 185
R1351 VDD.n1724 VDD.n1723 185
R1352 VDD.n1122 VDD.n940 185
R1353 VDD.n2522 VDD.n940 185
R1354 VDD.n1716 VDD.n1715 185
R1355 VDD.n1715 VDD.n1714 185
R1356 VDD.n1712 VDD.n928 185
R1357 VDD.n2531 VDD.n928 185
R1358 VDD.n1711 VDD.n1710 185
R1359 VDD.n1710 VDD.n927 185
R1360 VDD.n1709 VDD.n1124 185
R1361 VDD.n1709 VDD.n917 185
R1362 VDD.n1705 VDD.n916 185
R1363 VDD.n2542 VDD.n916 185
R1364 VDD.n1703 VDD.n1702 185
R1365 VDD.n1702 VDD.n1701 185
R1366 VDD.n1690 VDD.n1689 185
R1367 VDD.n1691 VDD.n1690 185
R1368 VDD.n1127 VDD.n896 185
R1369 VDD.n2554 VDD.n896 185
R1370 VDD.n1581 VDD.n1580 185
R1371 VDD.n1580 VDD.n895 185
R1372 VDD.n1579 VDD.n1578 185
R1373 VDD.n1579 VDD.n881 185
R1374 VDD.n1130 VDD.n880 185
R1375 VDD.n2565 VDD.n880 185
R1376 VDD.n1573 VDD.n1572 185
R1377 VDD.n1572 VDD.n1571 185
R1378 VDD.n1568 VDD.n870 185
R1379 VDD.n2574 VDD.n870 185
R1380 VDD.n1139 VDD.n1132 185
R1381 VDD.n1139 VDD.n869 185
R1382 VDD.n1560 VDD.n1559 185
R1383 VDD.n1559 VDD.n1558 185
R1384 VDD.n1138 VDD.n1136 185
R1385 VDD.n1138 VDD.n854 185
R1386 VDD.n1377 VDD.n853 185
R1387 VDD.n2585 VDD.n853 185
R1388 VDD.n1382 VDD.n1381 185
R1389 VDD.n1381 VDD.n1380 185
R1390 VDD.n1374 VDD.n842 185
R1391 VDD.n2594 VDD.n842 185
R1392 VDD.n1388 VDD.n1387 185
R1393 VDD.n1388 VDD.n841 185
R1394 VDD.n1392 VDD.n1391 185
R1395 VDD.n1391 VDD.n1390 185
R1396 VDD.n1393 VDD.n832 185
R1397 VDD.n2605 VDD.n832 185
R1398 VDD.n1373 VDD.n1372 185
R1399 VDD.n1372 VDD.n1371 185
R1400 VDD.n1358 VDD.n1357 185
R1401 VDD.n1359 VDD.n1358 185
R1402 VDD.n1354 VDD.n808 185
R1403 VDD.n2617 VDD.n808 185
R1404 VDD.n778 VDD.n758 185
R1405 VDD.n758 VDD.n757 185
R1406 VDD.n2688 VDD.n2687 185
R1407 VDD.n780 VDD.n765 185
R1408 VDD.n2684 VDD.n2683 185
R1409 VDD.n2685 VDD.n2684 185
R1410 VDD.n2682 VDD.n779 185
R1411 VDD.n2676 VDD.n782 185
R1412 VDD.n2678 VDD.n2677 185
R1413 VDD.n2674 VDD.n2673 185
R1414 VDD.n2672 VDD.n2671 185
R1415 VDD.n2664 VDD.n786 185
R1416 VDD.n2666 VDD.n2665 185
R1417 VDD.n2662 VDD.n2661 185
R1418 VDD.n2660 VDD.n2659 185
R1419 VDD.n2652 VDD.n790 185
R1420 VDD.n2654 VDD.n2653 185
R1421 VDD.n2650 VDD.n2649 185
R1422 VDD.n2648 VDD.n2647 185
R1423 VDD.n2640 VDD.n794 185
R1424 VDD.n2642 VDD.n2641 185
R1425 VDD.n2638 VDD.n2637 185
R1426 VDD.n2636 VDD.n2635 185
R1427 VDD.n801 VDD.n798 185
R1428 VDD.n2631 VDD.n802 185
R1429 VDD.n2630 VDD.n2629 185
R1430 VDD.n2628 VDD.n2627 185
R1431 VDD.n2620 VDD.n804 185
R1432 VDD.n2622 VDD.n2621 185
R1433 VDD.n2621 VDD.n766 185
R1434 VDD.n2619 VDD.n807 140.69
R1435 VDD.n1369 VDD.n807 140.69
R1436 VDD.n1369 VDD.n833 140.69
R1437 VDD.n2603 VDD.n833 140.69
R1438 VDD.n2603 VDD.n834 140.69
R1439 VDD.n2596 VDD.n834 140.69
R1440 VDD.n2596 VDD.n840 140.69
R1441 VDD.n855 VDD.n840 140.69
R1442 VDD.n2583 VDD.n855 140.69
R1443 VDD.n2583 VDD.n856 140.69
R1444 VDD.n867 VDD.n856 140.69
R1445 VDD.n2576 VDD.n867 140.69
R1446 VDD.n2576 VDD.n868 140.69
R1447 VDD.n882 VDD.n868 140.69
R1448 VDD.n2563 VDD.n882 140.69
R1449 VDD.n2563 VDD.n883 140.69
R1450 VDD.n2556 VDD.n883 140.69
R1451 VDD.n2556 VDD.n893 140.69
R1452 VDD.n1699 VDD.n893 140.69
R1453 VDD.n1699 VDD.n918 140.69
R1454 VDD.n2540 VDD.n918 140.69
R1455 VDD.n2540 VDD.n919 140.69
R1456 VDD.n2533 VDD.n919 140.69
R1457 VDD.n2533 VDD.n925 140.69
R1458 VDD.n941 VDD.n925 140.69
R1459 VDD.n2520 VDD.n941 140.69
R1460 VDD.n2520 VDD.n942 140.69
R1461 VDD.n2513 VDD.n942 140.69
R1462 VDD.n2513 VDD.n952 140.69
R1463 VDD.n971 VDD.n952 140.69
R1464 VDD.n2500 VDD.n971 140.69
R1465 VDD.n2500 VDD.n972 140.69
R1466 VDD.n2493 VDD.n972 140.69
R1467 VDD.n2493 VDD.n980 140.69
R1468 VDD.n1000 VDD.n980 140.69
R1469 VDD.n2480 VDD.n1000 140.69
R1470 VDD.n2480 VDD.n1001 140.69
R1471 VDD.n2473 VDD.n1001 140.69
R1472 VDD.n2473 VDD.n1011 140.69
R1473 VDD.n2336 VDD.n2302 140.69
R1474 VDD.n2336 VDD.n2303 140.69
R1475 VDD.n2329 VDD.n2303 140.69
R1476 VDD.n2329 VDD.n2311 140.69
R1477 VDD.n2325 VDD.n2311 140.69
R1478 VDD.n446 VDD.n275 140.69
R1479 VDD.n446 VDD.n270 140.69
R1480 VDD.n456 VDD.n270 140.69
R1481 VDD.n456 VDD.n261 140.69
R1482 VDD.n469 VDD.n261 140.69
R1483 VDD.n469 VDD.n256 140.69
R1484 VDD.n478 VDD.n256 140.69
R1485 VDD.n478 VDD.n247 140.69
R1486 VDD.n493 VDD.n247 140.69
R1487 VDD.n493 VDD.n242 140.69
R1488 VDD.n502 VDD.n242 140.69
R1489 VDD.n502 VDD.n231 140.69
R1490 VDD.n524 VDD.n231 140.69
R1491 VDD.n524 VDD.n232 140.69
R1492 VDD.n232 VDD.n227 140.69
R1493 VDD.n532 VDD.n227 140.69
R1494 VDD.n532 VDD.n65 140.69
R1495 VDD.n2876 VDD.n65 140.69
R1496 VDD.n2876 VDD.n66 140.69
R1497 VDD.n2872 VDD.n66 140.69
R1498 VDD.n2872 VDD.n72 140.69
R1499 VDD.n2865 VDD.n72 140.69
R1500 VDD.n2865 VDD.n79 140.69
R1501 VDD.n2861 VDD.n79 140.69
R1502 VDD.n2861 VDD.n84 140.69
R1503 VDD.n2854 VDD.n84 140.69
R1504 VDD.n2854 VDD.n91 140.69
R1505 VDD.n2850 VDD.n91 140.69
R1506 VDD.n2850 VDD.n96 140.69
R1507 VDD.n2843 VDD.n96 140.69
R1508 VDD.n2843 VDD.n103 140.69
R1509 VDD.n2839 VDD.n103 140.69
R1510 VDD.n2839 VDD.n108 140.69
R1511 VDD.n2833 VDD.n108 140.69
R1512 VDD.n2833 VDD.n116 140.69
R1513 VDD.n2829 VDD.n116 140.69
R1514 VDD.n2829 VDD.n121 140.69
R1515 VDD.n2822 VDD.n121 140.69
R1516 VDD.n2822 VDD.n126 140.69
R1517 VDD.n2818 VDD.n126 140.69
R1518 VDD.n2818 VDD.n131 140.69
R1519 VDD.n2811 VDD.n131 140.69
R1520 VDD.n2811 VDD.n138 140.69
R1521 VDD.n2807 VDD.n138 140.69
R1522 VDD.n2807 VDD.n143 140.69
R1523 VDD.n2742 VDD.n143 140.69
R1524 VDD.n2742 VDD.n710 140.69
R1525 VDD.n2735 VDD.n710 140.69
R1526 VDD.n2735 VDD.n715 140.69
R1527 VDD.n2731 VDD.n715 140.69
R1528 VDD.n2731 VDD.n720 140.69
R1529 VDD.n2725 VDD.n720 140.69
R1530 VDD.n2725 VDD.n727 140.69
R1531 VDD.n2721 VDD.n727 140.69
R1532 VDD.n2721 VDD.n732 140.69
R1533 VDD.n2714 VDD.n732 140.69
R1534 VDD.n2714 VDD.n737 140.69
R1535 VDD.n2710 VDD.n737 140.69
R1536 VDD.n2710 VDD.n742 140.69
R1537 VDD.n1241 VDD.n742 140.69
R1538 VDD.n1241 VDD.n753 140.69
R1539 VDD.n2699 VDD.n753 140.69
R1540 VDD.n2699 VDD.n754 140.69
R1541 VDD.n817 VDD.n754 140.69
R1542 VDD.n817 VDD.n810 140.69
R1543 VDD.n2616 VDD.n810 140.69
R1544 VDD.n2616 VDD.n811 140.69
R1545 VDD.n829 VDD.n811 140.69
R1546 VDD.n2606 VDD.n829 140.69
R1547 VDD.n2606 VDD.n830 140.69
R1548 VDD.n844 VDD.n830 140.69
R1549 VDD.n2593 VDD.n844 140.69
R1550 VDD.n2593 VDD.n845 140.69
R1551 VDD.n2586 VDD.n845 140.69
R1552 VDD.n2586 VDD.n852 140.69
R1553 VDD.n1557 VDD.n852 140.69
R1554 VDD.n1557 VDD.n871 140.69
R1555 VDD.n2573 VDD.n871 140.69
R1556 VDD.n2573 VDD.n872 140.69
R1557 VDD.n2566 VDD.n872 140.69
R1558 VDD.n2566 VDD.n878 140.69
R1559 VDD.n898 VDD.n878 140.69
R1560 VDD.n2553 VDD.n898 140.69
R1561 VDD.n2553 VDD.n899 140.69
R1562 VDD.n913 VDD.n899 140.69
R1563 VDD.n2543 VDD.n913 140.69
R1564 VDD.n2543 VDD.n914 140.69
R1565 VDD.n930 VDD.n914 140.69
R1566 VDD.n2530 VDD.n930 140.69
R1567 VDD.n2530 VDD.n931 140.69
R1568 VDD.n2523 VDD.n931 140.69
R1569 VDD.n2523 VDD.n938 140.69
R1570 VDD.n956 VDD.n938 140.69
R1571 VDD.n2510 VDD.n956 140.69
R1572 VDD.n2510 VDD.n957 140.69
R1573 VDD.n2503 VDD.n957 140.69
R1574 VDD.n2503 VDD.n968 140.69
R1575 VDD.n985 VDD.n968 140.69
R1576 VDD.n2490 VDD.n985 140.69
R1577 VDD.n2490 VDD.n986 140.69
R1578 VDD.n2483 VDD.n986 140.69
R1579 VDD.n2483 VDD.n996 140.69
R1580 VDD.n1016 VDD.n996 140.69
R1581 VDD.n2470 VDD.n1016 140.69
R1582 VDD.n2470 VDD.n1017 140.69
R1583 VDD.n2464 VDD.n1017 140.69
R1584 VDD.n2464 VDD.n1027 140.69
R1585 VDD.n2102 VDD.n1027 140.69
R1586 VDD.n2102 VDD.n1042 140.69
R1587 VDD.n2451 VDD.n1042 140.69
R1588 VDD.n2451 VDD.n1043 140.69
R1589 VDD.n2444 VDD.n1043 140.69
R1590 VDD.n2444 VDD.n1049 140.69
R1591 VDD.n2440 VDD.n1049 140.69
R1592 VDD.n2440 VDD.n1054 140.69
R1593 VDD.n2409 VDD.n1054 140.69
R1594 VDD.n2461 VDD.n1029 140.69
R1595 VDD.n2461 VDD.n1033 140.69
R1596 VDD.n2454 VDD.n1033 140.69
R1597 VDD.n2454 VDD.n2453 140.69
R1598 VDD.n2453 VDD.n1039 140.69
R1599 VDD.n1050 VDD.n1039 140.69
R1600 VDD.n1051 VDD.n1050 140.69
R1601 VDD.n1052 VDD.n1051 140.69
R1602 VDD.n2412 VDD.n1052 140.69
R1603 VDD.n2412 VDD.n2411 140.69
R1604 VDD.n2338 VDD.n2297 140.69
R1605 VDD.n2338 VDD.n2298 140.69
R1606 VDD.n2312 VDD.n2298 140.69
R1607 VDD.n2313 VDD.n2312 140.69
R1608 VDD.n2322 VDD.n2313 140.69
R1609 VDD.n444 VDD.n277 140.69
R1610 VDD.n444 VDD.n267 140.69
R1611 VDD.n458 VDD.n267 140.69
R1612 VDD.n458 VDD.n262 140.69
R1613 VDD.n467 VDD.n262 140.69
R1614 VDD.n467 VDD.n254 140.69
R1615 VDD.n480 VDD.n254 140.69
R1616 VDD.n480 VDD.n249 140.69
R1617 VDD.n491 VDD.n249 140.69
R1618 VDD.n491 VDD.n239 140.69
R1619 VDD.n504 VDD.n239 140.69
R1620 VDD.n505 VDD.n504 140.69
R1621 VDD.n505 VDD.n234 140.69
R1622 VDD.n521 VDD.n234 140.69
R1623 VDD.n521 VDD.n225 140.69
R1624 VDD.n534 VDD.n225 140.69
R1625 VDD.n535 VDD.n534 140.69
R1626 VDD.n535 VDD.n68 140.69
R1627 VDD.n69 VDD.n68 140.69
R1628 VDD.n70 VDD.n69 140.69
R1629 VDD.n219 VDD.n70 140.69
R1630 VDD.n219 VDD.n80 140.69
R1631 VDD.n81 VDD.n80 140.69
R1632 VDD.n82 VDD.n81 140.69
R1633 VDD.n555 VDD.n82 140.69
R1634 VDD.n555 VDD.n92 140.69
R1635 VDD.n93 VDD.n92 140.69
R1636 VDD.n94 VDD.n93 140.69
R1637 VDD.n565 VDD.n94 140.69
R1638 VDD.n565 VDD.n104 140.69
R1639 VDD.n105 VDD.n104 140.69
R1640 VDD.n106 VDD.n105 140.69
R1641 VDD.n209 VDD.n106 140.69
R1642 VDD.n209 VDD.n117 140.69
R1643 VDD.n118 VDD.n117 140.69
R1644 VDD.n119 VDD.n118 140.69
R1645 VDD.n206 VDD.n119 140.69
R1646 VDD.n206 VDD.n127 140.69
R1647 VDD.n128 VDD.n127 140.69
R1648 VDD.n129 VDD.n128 140.69
R1649 VDD.n695 VDD.n129 140.69
R1650 VDD.n695 VDD.n139 140.69
R1651 VDD.n140 VDD.n139 140.69
R1652 VDD.n141 VDD.n140 140.69
R1653 VDD.n707 VDD.n141 140.69
R1654 VDD.n2744 VDD.n707 140.69
R1655 VDD.n2744 VDD.n708 140.69
R1656 VDD.n716 VDD.n708 140.69
R1657 VDD.n717 VDD.n716 140.69
R1658 VDD.n718 VDD.n717 140.69
R1659 VDD.n1205 VDD.n718 140.69
R1660 VDD.n1205 VDD.n728 140.69
R1661 VDD.n729 VDD.n728 140.69
R1662 VDD.n730 VDD.n729 140.69
R1663 VDD.n1202 VDD.n730 140.69
R1664 VDD.n1202 VDD.n738 140.69
R1665 VDD.n739 VDD.n738 140.69
R1666 VDD.n740 VDD.n739 140.69
R1667 VDD.n1238 VDD.n740 140.69
R1668 VDD.n1243 VDD.n1238 140.69
R1669 VDD.n1244 VDD.n1243 140.69
R1670 VDD.n1244 VDD.n756 140.69
R1671 VDD.n2695 VDD.n756 140.69
R1672 VDD.n1358 VDD.n808 140.69
R1673 VDD.n1372 VDD.n1358 140.69
R1674 VDD.n1372 VDD.n832 140.69
R1675 VDD.n1391 VDD.n832 140.69
R1676 VDD.n1391 VDD.n1388 140.69
R1677 VDD.n1388 VDD.n842 140.69
R1678 VDD.n1381 VDD.n842 140.69
R1679 VDD.n1381 VDD.n853 140.69
R1680 VDD.n1138 VDD.n853 140.69
R1681 VDD.n1559 VDD.n1138 140.69
R1682 VDD.n1559 VDD.n1139 140.69
R1683 VDD.n1139 VDD.n870 140.69
R1684 VDD.n1572 VDD.n870 140.69
R1685 VDD.n1572 VDD.n880 140.69
R1686 VDD.n1579 VDD.n880 140.69
R1687 VDD.n1580 VDD.n1579 140.69
R1688 VDD.n1580 VDD.n896 140.69
R1689 VDD.n1690 VDD.n896 140.69
R1690 VDD.n1702 VDD.n1690 140.69
R1691 VDD.n1702 VDD.n916 140.69
R1692 VDD.n1709 VDD.n916 140.69
R1693 VDD.n1710 VDD.n1709 140.69
R1694 VDD.n1710 VDD.n928 140.69
R1695 VDD.n1715 VDD.n928 140.69
R1696 VDD.n1715 VDD.n940 140.69
R1697 VDD.n1724 VDD.n940 140.69
R1698 VDD.n1725 VDD.n1724 140.69
R1699 VDD.n1725 VDD.n954 140.69
R1700 VDD.n1729 VDD.n954 140.69
R1701 VDD.n1729 VDD.n969 140.69
R1702 VDD.n1876 VDD.n969 140.69
R1703 VDD.n1876 VDD.n1875 140.69
R1704 VDD.n1875 VDD.n983 140.69
R1705 VDD.n1868 VDD.n983 140.69
R1706 VDD.n1868 VDD.n998 140.69
R1707 VDD.n1858 VDD.n998 140.69
R1708 VDD.n1859 VDD.n1858 140.69
R1709 VDD.n1859 VDD.n1014 140.69
R1710 VDD.n808 VDD.n758 136.553
R1711 VDD.n1744 VDD.n1738 131.708
R1712 VDD.n1793 VDD.n1792 131.708
R1713 VDD.n2687 VDD.n758 131.708
R1714 VDD.n2621 VDD.n2620 131.708
R1715 VDD.n2695 VDD.n758 115.862
R1716 VDD.n2405 VDD.n2245 108.293
R1717 VDD.n2346 VDD.n2242 108.293
R1718 VDD.n388 VDD.n298 108.293
R1719 VDD.n390 VDD.n285 108.293
R1720 VDD.n1849 VDD.n1744 99.5127
R1721 VDD.n1847 VDD.n1747 99.5127
R1722 VDD.n1843 VDD.n1842 99.5127
R1723 VDD.n1840 VDD.n1752 99.5127
R1724 VDD.n1833 VDD.n1832 99.5127
R1725 VDD.n1830 VDD.n1761 99.5127
R1726 VDD.n1823 VDD.n1822 99.5127
R1727 VDD.n1820 VDD.n1769 99.5127
R1728 VDD.n1813 VDD.n1812 99.5127
R1729 VDD.n1810 VDD.n1777 99.5127
R1730 VDD.n1803 VDD.n1802 99.5127
R1731 VDD.n1800 VDD.n1784 99.5127
R1732 VDD.n2403 VDD.n2250 99.5127
R1733 VDD.n2396 VDD.n2395 99.5127
R1734 VDD.n2393 VDD.n2258 99.5127
R1735 VDD.n2386 VDD.n2385 99.5127
R1736 VDD.n2383 VDD.n2266 99.5127
R1737 VDD.n2376 VDD.n2375 99.5127
R1738 VDD.n2373 VDD.n2273 99.5127
R1739 VDD.n2366 VDD.n2365 99.5127
R1740 VDD.n2363 VDD.n2280 99.5127
R1741 VDD.n2356 VDD.n2355 99.5127
R1742 VDD.n2353 VDD.n2288 99.5127
R1743 VDD.n388 VDD.n299 99.5127
R1744 VDD.n381 VDD.n380 99.5127
R1745 VDD.n373 VDD.n372 99.5127
R1746 VDD.n369 VDD.n368 99.5127
R1747 VDD.n361 VDD.n360 99.5127
R1748 VDD.n357 VDD.n356 99.5127
R1749 VDD.n353 VDD.n352 99.5127
R1750 VDD.n345 VDD.n344 99.5127
R1751 VDD.n341 VDD.n340 99.5127
R1752 VDD.n333 VDD.n332 99.5127
R1753 VDD.n329 VDD.n328 99.5127
R1754 VDD.n390 VDD.n284 99.5127
R1755 VDD.n2684 VDD.n765 99.5127
R1756 VDD.n2684 VDD.n779 99.5127
R1757 VDD.n2677 VDD.n2676 99.5127
R1758 VDD.n2673 VDD.n2672 99.5127
R1759 VDD.n2665 VDD.n2664 99.5127
R1760 VDD.n2661 VDD.n2660 99.5127
R1761 VDD.n2653 VDD.n2652 99.5127
R1762 VDD.n2649 VDD.n2648 99.5127
R1763 VDD.n2641 VDD.n2640 99.5127
R1764 VDD.n2637 VDD.n2636 99.5127
R1765 VDD.n802 VDD.n801 99.5127
R1766 VDD.n2629 VDD.n2628 99.5127
R1767 VDD.n760 VDD.n758 92.5005
R1768 VDD.n1738 VDD.n1014 91.035
R1769 VDD.n2345 VDD.n2244 72.8958
R1770 VDD.n2354 VDD.n2244 72.8958
R1771 VDD.n2286 VDD.n2244 72.8958
R1772 VDD.n2364 VDD.n2244 72.8958
R1773 VDD.n2278 VDD.n2244 72.8958
R1774 VDD.n2374 VDD.n2244 72.8958
R1775 VDD.n2272 VDD.n2244 72.8958
R1776 VDD.n2384 VDD.n2244 72.8958
R1777 VDD.n2264 VDD.n2244 72.8958
R1778 VDD.n2394 VDD.n2244 72.8958
R1779 VDD.n2256 VDD.n2244 72.8958
R1780 VDD.n2404 VDD.n2244 72.8958
R1781 VDD.n1788 VDD.n1746 72.8958
R1782 VDD.n1801 VDD.n1746 72.8958
R1783 VDD.n1783 VDD.n1746 72.8958
R1784 VDD.n1811 VDD.n1746 72.8958
R1785 VDD.n1775 VDD.n1746 72.8958
R1786 VDD.n1821 VDD.n1746 72.8958
R1787 VDD.n1767 VDD.n1746 72.8958
R1788 VDD.n1831 VDD.n1746 72.8958
R1789 VDD.n1759 VDD.n1746 72.8958
R1790 VDD.n1841 VDD.n1746 72.8958
R1791 VDD.n1750 VDD.n1746 72.8958
R1792 VDD.n1848 VDD.n1746 72.8958
R1793 VDD.n389 VDD.n287 72.8958
R1794 VDD.n389 VDD.n288 72.8958
R1795 VDD.n389 VDD.n289 72.8958
R1796 VDD.n389 VDD.n290 72.8958
R1797 VDD.n389 VDD.n291 72.8958
R1798 VDD.n389 VDD.n292 72.8958
R1799 VDD.n389 VDD.n293 72.8958
R1800 VDD.n389 VDD.n294 72.8958
R1801 VDD.n389 VDD.n295 72.8958
R1802 VDD.n389 VDD.n296 72.8958
R1803 VDD.n389 VDD.n297 72.8958
R1804 VDD.n2686 VDD.n2685 72.8958
R1805 VDD.n2685 VDD.n767 72.8958
R1806 VDD.n2685 VDD.n768 72.8958
R1807 VDD.n2685 VDD.n769 72.8958
R1808 VDD.n2685 VDD.n770 72.8958
R1809 VDD.n2685 VDD.n771 72.8958
R1810 VDD.n2685 VDD.n772 72.8958
R1811 VDD.n2685 VDD.n773 72.8958
R1812 VDD.n2685 VDD.n774 72.8958
R1813 VDD.n2685 VDD.n775 72.8958
R1814 VDD.n2685 VDD.n776 72.8958
R1815 VDD.n2685 VDD.n777 72.8958
R1816 VDD.n2302 VDD.n2245 57.9315
R1817 VDD.n2297 VDD.n2242 57.9315
R1818 VDD.n2409 VDD.n2245 53.7936
R1819 VDD.n2411 VDD.n2242 53.7936
R1820 VDD.n298 VDD.n275 45.5177
R1821 VDD.n285 VDD.n277 45.5177
R1822 VDD.n2621 VDD.n2619 43.4488
R1823 VDD.n1792 VDD.n1011 43.4488
R1824 VDD.n1848 VDD.n1847 39.2114
R1825 VDD.n1843 VDD.n1750 39.2114
R1826 VDD.n1841 VDD.n1840 39.2114
R1827 VDD.n1833 VDD.n1759 39.2114
R1828 VDD.n1831 VDD.n1830 39.2114
R1829 VDD.n1823 VDD.n1767 39.2114
R1830 VDD.n1821 VDD.n1820 39.2114
R1831 VDD.n1813 VDD.n1775 39.2114
R1832 VDD.n1811 VDD.n1810 39.2114
R1833 VDD.n1803 VDD.n1783 39.2114
R1834 VDD.n1801 VDD.n1800 39.2114
R1835 VDD.n1793 VDD.n1788 39.2114
R1836 VDD.n2404 VDD.n2403 39.2114
R1837 VDD.n2396 VDD.n2256 39.2114
R1838 VDD.n2394 VDD.n2393 39.2114
R1839 VDD.n2386 VDD.n2264 39.2114
R1840 VDD.n2384 VDD.n2383 39.2114
R1841 VDD.n2376 VDD.n2272 39.2114
R1842 VDD.n2374 VDD.n2373 39.2114
R1843 VDD.n2366 VDD.n2278 39.2114
R1844 VDD.n2364 VDD.n2363 39.2114
R1845 VDD.n2356 VDD.n2286 39.2114
R1846 VDD.n2354 VDD.n2353 39.2114
R1847 VDD.n2346 VDD.n2345 39.2114
R1848 VDD.n2345 VDD.n2288 39.2114
R1849 VDD.n2355 VDD.n2354 39.2114
R1850 VDD.n2286 VDD.n2280 39.2114
R1851 VDD.n2365 VDD.n2364 39.2114
R1852 VDD.n2278 VDD.n2273 39.2114
R1853 VDD.n2375 VDD.n2374 39.2114
R1854 VDD.n2272 VDD.n2266 39.2114
R1855 VDD.n2385 VDD.n2384 39.2114
R1856 VDD.n2264 VDD.n2258 39.2114
R1857 VDD.n2395 VDD.n2394 39.2114
R1858 VDD.n2256 VDD.n2250 39.2114
R1859 VDD.n2405 VDD.n2404 39.2114
R1860 VDD.n1788 VDD.n1784 39.2114
R1861 VDD.n1802 VDD.n1801 39.2114
R1862 VDD.n1783 VDD.n1777 39.2114
R1863 VDD.n1812 VDD.n1811 39.2114
R1864 VDD.n1775 VDD.n1769 39.2114
R1865 VDD.n1822 VDD.n1821 39.2114
R1866 VDD.n1767 VDD.n1761 39.2114
R1867 VDD.n1832 VDD.n1831 39.2114
R1868 VDD.n1759 VDD.n1752 39.2114
R1869 VDD.n1842 VDD.n1841 39.2114
R1870 VDD.n1750 VDD.n1747 39.2114
R1871 VDD.n1849 VDD.n1848 39.2114
R1872 VDD.n299 VDD.n287 39.2114
R1873 VDD.n380 VDD.n288 39.2114
R1874 VDD.n373 VDD.n289 39.2114
R1875 VDD.n368 VDD.n290 39.2114
R1876 VDD.n361 VDD.n291 39.2114
R1877 VDD.n356 VDD.n292 39.2114
R1878 VDD.n352 VDD.n293 39.2114
R1879 VDD.n345 VDD.n294 39.2114
R1880 VDD.n340 VDD.n295 39.2114
R1881 VDD.n333 VDD.n296 39.2114
R1882 VDD.n328 VDD.n297 39.2114
R1883 VDD.n381 VDD.n287 39.2114
R1884 VDD.n372 VDD.n288 39.2114
R1885 VDD.n369 VDD.n289 39.2114
R1886 VDD.n360 VDD.n290 39.2114
R1887 VDD.n357 VDD.n291 39.2114
R1888 VDD.n353 VDD.n292 39.2114
R1889 VDD.n344 VDD.n293 39.2114
R1890 VDD.n341 VDD.n294 39.2114
R1891 VDD.n332 VDD.n295 39.2114
R1892 VDD.n329 VDD.n296 39.2114
R1893 VDD.n297 VDD.n284 39.2114
R1894 VDD.n2687 VDD.n2686 39.2114
R1895 VDD.n779 VDD.n767 39.2114
R1896 VDD.n2677 VDD.n768 39.2114
R1897 VDD.n2672 VDD.n769 39.2114
R1898 VDD.n2665 VDD.n770 39.2114
R1899 VDD.n2660 VDD.n771 39.2114
R1900 VDD.n2653 VDD.n772 39.2114
R1901 VDD.n2648 VDD.n773 39.2114
R1902 VDD.n2641 VDD.n774 39.2114
R1903 VDD.n2636 VDD.n775 39.2114
R1904 VDD.n802 VDD.n776 39.2114
R1905 VDD.n2628 VDD.n777 39.2114
R1906 VDD.n2686 VDD.n765 39.2114
R1907 VDD.n2676 VDD.n767 39.2114
R1908 VDD.n2673 VDD.n768 39.2114
R1909 VDD.n2664 VDD.n769 39.2114
R1910 VDD.n2661 VDD.n770 39.2114
R1911 VDD.n2652 VDD.n771 39.2114
R1912 VDD.n2649 VDD.n772 39.2114
R1913 VDD.n2640 VDD.n773 39.2114
R1914 VDD.n2637 VDD.n774 39.2114
R1915 VDD.n801 VDD.n775 39.2114
R1916 VDD.n2629 VDD.n776 39.2114
R1917 VDD.n2620 VDD.n777 39.2114
R1918 VDD.n2452 VDD.n1032 29.8802
R1919 VDD.n2452 VDD.n1041 29.8802
R1920 VDD.n2443 VDD.n1041 29.8802
R1921 VDD.n2442 VDD.n2441 29.8802
R1922 VDD.n2441 VDD.n1053 29.8802
R1923 VDD.n2410 VDD.n1053 29.8802
R1924 VDD.n2300 VDD.n2299 29.8802
R1925 VDD.n2337 VDD.n2300 29.8802
R1926 VDD.n2337 VDD.n2301 29.8802
R1927 VDD.n2328 VDD.n2301 29.8802
R1928 VDD.n2328 VDD.n2327 29.8802
R1929 VDD.n2327 VDD.n2326 29.8802
R1930 VDD.n445 VDD.n276 29.688
R1931 VDD.n445 VDD.n268 29.688
R1932 VDD.n457 VDD.n268 29.688
R1933 VDD.n457 VDD.n269 29.688
R1934 VDD.n468 VDD.n255 29.688
R1935 VDD.n479 VDD.n255 29.688
R1936 VDD.n479 VDD.n248 29.688
R1937 VDD.n492 VDD.n248 29.688
R1938 VDD.n492 VDD.n241 29.688
R1939 VDD.n503 VDD.n241 29.688
R1940 VDD.n523 VDD.n233 29.688
R1941 VDD.n523 VDD.n522 29.688
R1942 VDD.n522 VDD.n226 29.688
R1943 VDD.n533 VDD.n226 29.688
R1944 VDD.n533 VDD.n67 29.688
R1945 VDD.n2875 VDD.n67 29.688
R1946 VDD.n2875 VDD.n2874 29.688
R1947 VDD.n2873 VDD.n71 29.688
R1948 VDD.n2864 VDD.n71 29.688
R1949 VDD.n2864 VDD.n2863 29.688
R1950 VDD.n2863 VDD.n2862 29.688
R1951 VDD.n2862 VDD.n83 29.688
R1952 VDD.n2853 VDD.n83 29.688
R1953 VDD.n2852 VDD.n2851 29.688
R1954 VDD.n2851 VDD.n95 29.688
R1955 VDD.n2842 VDD.n95 29.688
R1956 VDD.n2842 VDD.n2841 29.688
R1957 VDD.n2841 VDD.n2840 29.688
R1958 VDD.n2840 VDD.n107 29.688
R1959 VDD.n2832 VDD.n2831 29.688
R1960 VDD.n2831 VDD.n2830 29.688
R1961 VDD.n2830 VDD.n120 29.688
R1962 VDD.n2821 VDD.n120 29.688
R1963 VDD.n2821 VDD.n2820 29.688
R1964 VDD.n2820 VDD.n2819 29.688
R1965 VDD.n2819 VDD.n130 29.688
R1966 VDD.n2810 VDD.n2809 29.688
R1967 VDD.n2809 VDD.n2808 29.688
R1968 VDD.n2808 VDD.n142 29.688
R1969 VDD.n2743 VDD.n142 29.688
R1970 VDD.n2743 VDD.n709 29.688
R1971 VDD.n2734 VDD.n709 29.688
R1972 VDD.n2733 VDD.n2732 29.688
R1973 VDD.n2732 VDD.n719 29.688
R1974 VDD.n2724 VDD.n719 29.688
R1975 VDD.n2724 VDD.n2723 29.688
R1976 VDD.n2723 VDD.n2722 29.688
R1977 VDD.n2722 VDD.n731 29.688
R1978 VDD.n2713 VDD.n2712 29.688
R1979 VDD.n2712 VDD.n2711 29.688
R1980 VDD.n2711 VDD.n741 29.688
R1981 VDD.n1242 VDD.n741 29.688
R1982 VDD.n1242 VDD.n755 29.688
R1983 VDD.n2698 VDD.n755 29.688
R1984 VDD.n2410 VDD.n2244 29.4408
R1985 VDD.t12 VDD.n731 28.8148
R1986 VDD.n389 VDD.n276 27.5051
R1987 VDD.n2046 VDD.n1999 27.1064
R1988 VDD.n2038 VDD.n2037 27.1064
R1989 VDD.n2013 VDD.n2012 27.1064
R1990 VDD.n2027 VDD.n2026 27.1064
R1991 VDD.n2019 VDD.n2018 27.1064
R1992 VDD.n2061 VDD.n2060 27.1064
R1993 VDD.n1997 VDD.n1994 27.1064
R1994 VDD.n2049 VDD.n1986 27.1064
R1995 VDD.n1948 VDD.n1901 27.1064
R1996 VDD.n1939 VDD.n1938 27.1064
R1997 VDD.n1915 VDD.n1914 27.1064
R1998 VDD.n1928 VDD.n1927 27.1064
R1999 VDD.n1919 VDD.n1918 27.1064
R2000 VDD.n1963 VDD.n1962 27.1064
R2001 VDD.n1895 VDD.n1892 27.1064
R2002 VDD.n1951 VDD.n1116 27.1064
R2003 VDD.n1679 VDD.n1595 27.1064
R2004 VDD.n1668 VDD.n1667 27.1064
R2005 VDD.n1664 VDD.n1663 27.1064
R2006 VDD.n1612 VDD.n1611 27.1064
R2007 VDD.n1615 VDD.n1614 27.1064
R2008 VDD.n1646 VDD.n1645 27.1064
R2009 VDD.n1630 VDD.n1629 27.1064
R2010 VDD.n1633 VDD.n1587 27.1064
R2011 VDD.n1536 VDD.n1148 27.1064
R2012 VDD.n1540 VDD.n1156 27.1064
R2013 VDD.n1534 VDD.n1157 27.1064
R2014 VDD.n1479 VDD.n1163 27.1064
R2015 VDD.n1482 VDD.n1481 27.1064
R2016 VDD.n1517 VDD.n1516 27.1064
R2017 VDD.n1496 VDD.n1495 27.1064
R2018 VDD.n1505 VDD.n1504 27.1064
R2019 VDD.n2154 VDD.n2098 27.1064
R2020 VDD.n2145 VDD.n2144 27.1064
R2021 VDD.n2121 VDD.n2120 27.1064
R2022 VDD.n2134 VDD.n2133 27.1064
R2023 VDD.n2125 VDD.n2124 27.1064
R2024 VDD.n2169 VDD.n2168 27.1064
R2025 VDD.n2096 VDD.n2093 27.1064
R2026 VDD.n2157 VDD.n2084 27.1064
R2027 VDD.n1073 VDD.n1063 27.1064
R2028 VDD.n2423 VDD.n1071 27.1064
R2029 VDD.n2177 VDD.n1072 27.1064
R2030 VDD.n2192 VDD.n2191 27.1064
R2031 VDD.n2196 VDD.n2195 27.1064
R2032 VDD.n2210 VDD.n2209 27.1064
R2033 VDD.n2206 VDD.n2205 27.1064
R2034 VDD.n2220 VDD.n1080 27.1064
R2035 VDD.n1455 VDD.n1409 27.1064
R2036 VDD.n1444 VDD.n1443 27.1064
R2037 VDD.n1440 VDD.n1439 27.1064
R2038 VDD.n1429 VDD.n1428 27.1064
R2039 VDD.n1423 VDD.n1422 27.1064
R2040 VDD.n1470 VDD.n1469 27.1064
R2041 VDD.n1407 VDD.n1404 27.1064
R2042 VDD.n1458 VDD.n1346 27.1064
R2043 VDD.n1308 VDD.n1261 27.1064
R2044 VDD.n1297 VDD.n1296 27.1064
R2045 VDD.n1293 VDD.n1292 27.1064
R2046 VDD.n1282 VDD.n1281 27.1064
R2047 VDD.n1275 VDD.n1274 27.1064
R2048 VDD.n1323 VDD.n1322 27.1064
R2049 VDD.n1259 VDD.n1256 27.1064
R2050 VDD.n1311 VDD.n1191 27.1064
R2051 VDD.n2786 VDD.n151 27.1064
R2052 VDD.n2790 VDD.n159 27.1064
R2053 VDD.n2784 VDD.n160 27.1064
R2054 VDD.n177 VDD.n166 27.1064
R2055 VDD.n180 VDD.n179 27.1064
R2056 VDD.n2767 VDD.n2766 27.1064
R2057 VDD.n194 VDD.n193 27.1064
R2058 VDD.n2755 VDD.n2754 27.1064
R2059 VDD.n665 VDD.n580 27.1064
R2060 VDD.n656 VDD.n655 27.1064
R2061 VDD.n594 VDD.n593 27.1064
R2062 VDD.n645 VDD.n644 27.1064
R2063 VDD.n636 VDD.n635 27.1064
R2064 VDD.n608 VDD.n607 27.1064
R2065 VDD.n625 VDD.n624 27.1064
R2066 VDD.n611 VDD.n572 27.1064
R2067 VDD.n2927 VDD.n58 27.1064
R2068 VDD.n2918 VDD.n2917 27.1064
R2069 VDD.n2894 VDD.n2893 27.1064
R2070 VDD.n2907 VDD.n2906 27.1064
R2071 VDD.n2898 VDD.n2897 27.1064
R2072 VDD.n2942 VDD.n2941 27.1064
R2073 VDD.n52 VDD.n49 27.1064
R2074 VDD.n2930 VDD.n47 27.1064
R2075 VDD.n2976 VDD.n11 27.1064
R2076 VDD.n2967 VDD.n2966 27.1064
R2077 VDD.n2955 VDD.n2954 27.1064
R2078 VDD.n2979 VDD.n2 27.1064
R2079 VDD.n408 VDD.n3 27.1064
R2080 VDD.n413 VDD.n412 27.1064
R2081 VDD.n423 VDD.n422 27.1064
R2082 VDD.n427 VDD.n426 27.1064
R2083 VDD.t23 VDD.n107 27.0685
R2084 VDD.n2443 VDD.t14 26.365
R2085 VDD.n503 VDD.t7 25.3222
R2086 VDD.t4 VDD.n2873 23.5759
R2087 VDD.n2698 VDD.n2697 23.5759
R2088 VDD.n2048 VDD.n1989 22.5471
R2089 VDD.n1950 VDD.n1890 22.5471
R2090 VDD.n1682 VDD.n1681 22.5471
R2091 VDD.n1500 VDD.n1158 22.5471
R2092 VDD.n2156 VDD.n2088 22.5471
R2093 VDD.n2420 VDD.n2419 22.5471
R2094 VDD.n1457 VDD.n1399 22.5471
R2095 VDD.n1310 VDD.n1251 22.5471
R2096 VDD.n198 VDD.n161 22.5471
R2097 VDD.n668 VDD.n667 22.5471
R2098 VDD.n2929 VDD.n48 22.5471
R2099 VDD.n437 VDD.n10 22.5471
R2100 VDD.n2810 VDD.t27 21.8295
R2101 VDD.n1738 VDD.n1029 20.6902
R2102 VDD.n1031 VDD.n1030 19.3345
R2103 VDD.n2734 VDD.t25 18.3369
R2104 VDD.n2853 VDD.t9 16.5906
R2105 VDD.t32 VDD.n1032 15.8192
R2106 VDD.n236 VDD.n224 15.0074
R2107 VDD.n536 VDD.n224 15.0074
R2108 VDD.n680 VDD.n210 15.0074
R2109 VDD.n681 VDD.n680 15.0074
R2110 VDD.n1221 VDD.n1206 15.0074
R2111 VDD.n1222 VDD.n1221 15.0074
R2112 VDD.n865 VDD.n858 15.0074
R2113 VDD.n2514 VDD.n951 15.0074
R2114 VDD.n2460 VDD.n1034 15.0074
R2115 VDD.n1393 VDD.n1392 15.0074
R2116 VDD.n1392 VDD.n1387 15.0074
R2117 VDD.n1711 VDD.n1124 15.0074
R2118 VDD.n1712 VDD.n1711 15.0074
R2119 VDD.n531 VDD.n530 15.0074
R2120 VDD.n531 VDD.n63 15.0074
R2121 VDD.n2834 VDD.n111 15.0074
R2122 VDD.n2834 VDD.n115 15.0074
R2123 VDD.n2726 VDD.n723 15.0074
R2124 VDD.n2726 VDD.n726 15.0074
R2125 VDD.n2607 VDD.n828 15.0074
R2126 VDD.n846 VDD.n828 15.0074
R2127 VDD.n933 VDD.n932 15.0074
R2128 VDD.n2529 VDD.n933 15.0074
R2129 VDD.n2465 VDD.n1019 15.0074
R2130 VDD.n2465 VDD.n1026 15.0074
R2131 VDD.n269 VDD.t34 14.8443
R2132 VDD.n468 VDD.t34 14.8443
R2133 VDD.n2582 VDD.n2581 14.566
R2134 VDD.n2578 VDD.n2577 14.566
R2135 VDD.n2515 VDD.n944 14.566
R2136 VDD.n974 VDD.n973 14.566
R2137 VDD.n520 VDD.n519 14.1246
R2138 VDD.n537 VDD.n222 14.1246
R2139 VDD.n677 VDD.n676 14.1246
R2140 VDD.n683 VDD.n682 14.1246
R2141 VDD.n1218 VDD.n1217 14.1246
R2142 VDD.n1224 VDD.n1223 14.1246
R2143 VDD.n2321 VDD.n2314 14.1246
R2144 VDD.n2324 VDD.n2323 14.1246
R2145 VDD.n2459 VDD.n1035 14.1246
R2146 VDD.n1394 VDD.n1373 14.1246
R2147 VDD.n1386 VDD.n1374 14.1246
R2148 VDD.n1706 VDD.n1705 14.1246
R2149 VDD.n1716 VDD.n1713 14.1246
R2150 VDD.n529 VDD.n228 14.1246
R2151 VDD.n2878 VDD.n2877 14.1246
R2152 VDD.n2838 VDD.n2837 14.1246
R2153 VDD.n2828 VDD.n122 14.1246
R2154 VDD.n2730 VDD.n2729 14.1246
R2155 VDD.n2720 VDD.n733 14.1246
R2156 VDD.n2608 VDD.n827 14.1246
R2157 VDD.n2592 VDD.n847 14.1246
R2158 VDD.n2544 VDD.n912 14.1246
R2159 VDD.n2528 VDD.n934 14.1246
R2160 VDD.n2469 VDD.n2468 14.1246
R2161 VDD.n2103 VDD.n2101 14.1246
R2162 VDD.t32 VDD.n1031 14.0616
R2163 VDD.n860 VDD.n857 13.6833
R2164 VDD.n886 VDD.n866 13.6833
R2165 VDD.n2519 VDD.n2518 13.6833
R2166 VDD.n2499 VDD.n975 13.6833
R2167 VDD.n1999 VDD.n1990 13.2471
R2168 VDD.n2037 VDD.n1991 13.2471
R2169 VDD.n2013 VDD.n1992 13.2471
R2170 VDD.n2026 VDD.n1993 13.2471
R2171 VDD.n2018 VDD.n1974 13.2471
R2172 VDD.n2060 VDD.n1975 13.2471
R2173 VDD.n1998 VDD.n1997 13.2471
R2174 VDD.n2049 VDD.n2048 13.2471
R2175 VDD.n2038 VDD.n1990 13.2471
R2176 VDD.n2012 VDD.n1991 13.2471
R2177 VDD.n2027 VDD.n1992 13.2471
R2178 VDD.n2019 VDD.n1993 13.2471
R2179 VDD.n2061 VDD.n1974 13.2471
R2180 VDD.n1994 VDD.n1975 13.2471
R2181 VDD.n1998 VDD.n1986 13.2471
R2182 VDD.n1939 VDD.n1900 13.2471
R2183 VDD.n1914 VDD.n1899 13.2471
R2184 VDD.n1928 VDD.n1898 13.2471
R2185 VDD.n1919 VDD.n1897 13.2471
R2186 VDD.n1963 VDD.n1105 13.2471
R2187 VDD.n1892 VDD.n1106 13.2471
R2188 VDD.n1896 VDD.n1116 13.2471
R2189 VDD.n1901 VDD.n1900 13.2471
R2190 VDD.n1938 VDD.n1899 13.2471
R2191 VDD.n1915 VDD.n1898 13.2471
R2192 VDD.n1927 VDD.n1897 13.2471
R2193 VDD.n1918 VDD.n1105 13.2471
R2194 VDD.n1962 VDD.n1106 13.2471
R2195 VDD.n1896 VDD.n1895 13.2471
R2196 VDD.n1951 VDD.n1950 13.2471
R2197 VDD.n1667 VDD.n1594 13.2471
R2198 VDD.n1664 VDD.n1593 13.2471
R2199 VDD.n1611 VDD.n1592 13.2471
R2200 VDD.n1614 VDD.n1591 13.2471
R2201 VDD.n1646 VDD.n1590 13.2471
R2202 VDD.n1629 VDD.n1589 13.2471
R2203 VDD.n1633 VDD.n1588 13.2471
R2204 VDD.n1595 VDD.n1594 13.2471
R2205 VDD.n1668 VDD.n1593 13.2471
R2206 VDD.n1663 VDD.n1592 13.2471
R2207 VDD.n1612 VDD.n1591 13.2471
R2208 VDD.n1615 VDD.n1590 13.2471
R2209 VDD.n1645 VDD.n1589 13.2471
R2210 VDD.n1630 VDD.n1588 13.2471
R2211 VDD.n1681 VDD.n1587 13.2471
R2212 VDD.n1537 VDD.n1156 13.2471
R2213 VDD.n1539 VDD.n1157 13.2471
R2214 VDD.n1535 VDD.n1163 13.2471
R2215 VDD.n1481 VDD.n1162 13.2471
R2216 VDD.n1517 VDD.n1161 13.2471
R2217 VDD.n1495 VDD.n1160 13.2471
R2218 VDD.n1504 VDD.n1159 13.2471
R2219 VDD.n1537 VDD.n1536 13.2471
R2220 VDD.n1540 VDD.n1539 13.2471
R2221 VDD.n1535 VDD.n1534 13.2471
R2222 VDD.n1479 VDD.n1162 13.2471
R2223 VDD.n1482 VDD.n1161 13.2471
R2224 VDD.n1516 VDD.n1160 13.2471
R2225 VDD.n1496 VDD.n1159 13.2471
R2226 VDD.n1505 VDD.n1158 13.2471
R2227 VDD.n2098 VDD.n2089 13.2471
R2228 VDD.n2144 VDD.n2090 13.2471
R2229 VDD.n2121 VDD.n2091 13.2471
R2230 VDD.n2133 VDD.n2092 13.2471
R2231 VDD.n2124 VDD.n2072 13.2471
R2232 VDD.n2168 VDD.n2073 13.2471
R2233 VDD.n2097 VDD.n2096 13.2471
R2234 VDD.n2157 VDD.n2156 13.2471
R2235 VDD.n2145 VDD.n2089 13.2471
R2236 VDD.n2120 VDD.n2090 13.2471
R2237 VDD.n2134 VDD.n2091 13.2471
R2238 VDD.n2125 VDD.n2092 13.2471
R2239 VDD.n2169 VDD.n2072 13.2471
R2240 VDD.n2093 VDD.n2073 13.2471
R2241 VDD.n2097 VDD.n2084 13.2471
R2242 VDD.n1074 VDD.n1073 13.2471
R2243 VDD.n2423 VDD.n2422 13.2471
R2244 VDD.n2177 VDD.n1075 13.2471
R2245 VDD.n2192 VDD.n1076 13.2471
R2246 VDD.n2195 VDD.n1077 13.2471
R2247 VDD.n2210 VDD.n1078 13.2471
R2248 VDD.n2205 VDD.n1079 13.2471
R2249 VDD.n2420 VDD.n1080 13.2471
R2250 VDD.n1074 VDD.n1071 13.2471
R2251 VDD.n2422 VDD.n1072 13.2471
R2252 VDD.n2191 VDD.n1075 13.2471
R2253 VDD.n2196 VDD.n1076 13.2471
R2254 VDD.n2209 VDD.n1077 13.2471
R2255 VDD.n2206 VDD.n1078 13.2471
R2256 VDD.n2220 VDD.n1079 13.2471
R2257 VDD.n1409 VDD.n1400 13.2471
R2258 VDD.n1444 VDD.n1401 13.2471
R2259 VDD.n1439 VDD.n1402 13.2471
R2260 VDD.n1429 VDD.n1403 13.2471
R2261 VDD.n1422 VDD.n1333 13.2471
R2262 VDD.n1469 VDD.n1334 13.2471
R2263 VDD.n1408 VDD.n1407 13.2471
R2264 VDD.n1458 VDD.n1457 13.2471
R2265 VDD.n1443 VDD.n1400 13.2471
R2266 VDD.n1440 VDD.n1401 13.2471
R2267 VDD.n1428 VDD.n1402 13.2471
R2268 VDD.n1423 VDD.n1403 13.2471
R2269 VDD.n1470 VDD.n1333 13.2471
R2270 VDD.n1404 VDD.n1334 13.2471
R2271 VDD.n1408 VDD.n1346 13.2471
R2272 VDD.n1261 VDD.n1252 13.2471
R2273 VDD.n1297 VDD.n1253 13.2471
R2274 VDD.n1292 VDD.n1254 13.2471
R2275 VDD.n1282 VDD.n1255 13.2471
R2276 VDD.n1275 VDD.n1179 13.2471
R2277 VDD.n1322 VDD.n1180 13.2471
R2278 VDD.n1260 VDD.n1259 13.2471
R2279 VDD.n1311 VDD.n1310 13.2471
R2280 VDD.n1296 VDD.n1252 13.2471
R2281 VDD.n1293 VDD.n1253 13.2471
R2282 VDD.n1281 VDD.n1254 13.2471
R2283 VDD.n1274 VDD.n1255 13.2471
R2284 VDD.n1323 VDD.n1179 13.2471
R2285 VDD.n1256 VDD.n1180 13.2471
R2286 VDD.n1260 VDD.n1191 13.2471
R2287 VDD.n2787 VDD.n159 13.2471
R2288 VDD.n2789 VDD.n160 13.2471
R2289 VDD.n2785 VDD.n166 13.2471
R2290 VDD.n179 VDD.n165 13.2471
R2291 VDD.n2767 VDD.n164 13.2471
R2292 VDD.n193 VDD.n163 13.2471
R2293 VDD.n2754 VDD.n162 13.2471
R2294 VDD.n2787 VDD.n2786 13.2471
R2295 VDD.n2790 VDD.n2789 13.2471
R2296 VDD.n2785 VDD.n2784 13.2471
R2297 VDD.n177 VDD.n165 13.2471
R2298 VDD.n180 VDD.n164 13.2471
R2299 VDD.n2766 VDD.n163 13.2471
R2300 VDD.n194 VDD.n162 13.2471
R2301 VDD.n2755 VDD.n161 13.2471
R2302 VDD.n656 VDD.n579 13.2471
R2303 VDD.n593 VDD.n578 13.2471
R2304 VDD.n645 VDD.n577 13.2471
R2305 VDD.n635 VDD.n576 13.2471
R2306 VDD.n607 VDD.n575 13.2471
R2307 VDD.n625 VDD.n574 13.2471
R2308 VDD.n611 VDD.n573 13.2471
R2309 VDD.n580 VDD.n579 13.2471
R2310 VDD.n655 VDD.n578 13.2471
R2311 VDD.n594 VDD.n577 13.2471
R2312 VDD.n644 VDD.n576 13.2471
R2313 VDD.n636 VDD.n575 13.2471
R2314 VDD.n608 VDD.n574 13.2471
R2315 VDD.n624 VDD.n573 13.2471
R2316 VDD.n667 VDD.n572 13.2471
R2317 VDD.n2918 VDD.n57 13.2471
R2318 VDD.n2893 VDD.n56 13.2471
R2319 VDD.n2907 VDD.n55 13.2471
R2320 VDD.n2898 VDD.n54 13.2471
R2321 VDD.n2942 VDD.n35 13.2471
R2322 VDD.n49 VDD.n36 13.2471
R2323 VDD.n53 VDD.n47 13.2471
R2324 VDD.n58 VDD.n57 13.2471
R2325 VDD.n2917 VDD.n56 13.2471
R2326 VDD.n2894 VDD.n55 13.2471
R2327 VDD.n2906 VDD.n54 13.2471
R2328 VDD.n2897 VDD.n35 13.2471
R2329 VDD.n2941 VDD.n36 13.2471
R2330 VDD.n53 VDD.n52 13.2471
R2331 VDD.n2930 VDD.n2929 13.2471
R2332 VDD.n11 VDD.n4 13.2471
R2333 VDD.n2966 VDD.n5 13.2471
R2334 VDD.n2955 VDD.n6 13.2471
R2335 VDD.n2979 VDD.n2978 13.2471
R2336 VDD.n408 VDD.n7 13.2471
R2337 VDD.n412 VDD.n8 13.2471
R2338 VDD.n423 VDD.n9 13.2471
R2339 VDD.n426 VDD.n10 13.2471
R2340 VDD.n2967 VDD.n4 13.2471
R2341 VDD.n2954 VDD.n5 13.2471
R2342 VDD.n6 VDD.n2 13.2471
R2343 VDD.n2978 VDD.n3 13.2471
R2344 VDD.n413 VDD.n7 13.2471
R2345 VDD.n422 VDD.n8 13.2471
R2346 VDD.n427 VDD.n9 13.2471
R2347 VDD.n443 VDD.n278 13.2419
R2348 VDD.n507 VDD.n235 13.2419
R2349 VDD.n541 VDD.n540 13.2419
R2350 VDD.n675 VDD.n674 13.2419
R2351 VDD.n684 VDD.n207 13.2419
R2352 VDD.n1216 VDD.n1215 13.2419
R2353 VDD.n1225 VDD.n1203 13.2419
R2354 VDD.n2319 VDD.n2318 13.2419
R2355 VDD.n2330 VDD.n2310 13.2419
R2356 VDD.n2456 VDD.n2455 13.2419
R2357 VDD.n1357 VDD.n1352 13.2419
R2358 VDD.n1383 VDD.n1382 13.2419
R2359 VDD.n1704 VDD.n1703 13.2419
R2360 VDD.n1717 VDD.n1122 13.2419
R2361 VDD.n1860 VDD.n1857 13.2419
R2362 VDD.n447 VDD.n274 13.2419
R2363 VDD.n526 VDD.n525 13.2419
R2364 VDD.n73 VDD.n64 13.2419
R2365 VDD.n110 VDD.n109 13.2419
R2366 VDD.n2827 VDD.n123 13.2419
R2367 VDD.n722 VDD.n721 13.2419
R2368 VDD.n2719 VDD.n734 13.2419
R2369 VDD.n826 VDD.n813 13.2419
R2370 VDD.n2591 VDD.n848 13.2419
R2371 VDD.n2545 VDD.n911 13.2419
R2372 VDD.n2525 VDD.n2524 13.2419
R2373 VDD.n1021 VDD.n1018 13.2419
R2374 VDD.n2105 VDD.n2104 13.2419
R2375 VDD.t9 VDD.n2852 13.0979
R2376 VDD.n861 VDD.n859 12.8005
R2377 VDD.n888 VDD.n887 12.8005
R2378 VDD.n946 VDD.n943 12.8005
R2379 VDD.n2498 VDD.n976 12.8005
R2380 VDD.n442 VDD.n279 12.3591
R2381 VDD.n508 VDD.n506 12.3591
R2382 VDD.n543 VDD.n542 12.3591
R2383 VDD.n673 VDD.n212 12.3591
R2384 VDD.n688 VDD.n687 12.3591
R2385 VDD.n1214 VDD.n1208 12.3591
R2386 VDD.n1229 VDD.n1228 12.3591
R2387 VDD.n2317 VDD.n2316 12.3591
R2388 VDD.n2331 VDD.n2306 12.3591
R2389 VDD.n1040 VDD.n1038 12.3591
R2390 VDD.n1356 VDD.n1354 12.3591
R2391 VDD.n1378 VDD.n1377 12.3591
R2392 VDD.n1689 VDD.n1126 12.3591
R2393 VDD.n1721 VDD.n1720 12.3591
R2394 VDD.n1861 VDD.n1736 12.3591
R2395 VDD.n449 VDD.n448 12.3591
R2396 VDD.n244 VDD.n230 12.3591
R2397 VDD.n2871 VDD.n74 12.3591
R2398 VDD.n2844 VDD.n102 12.3591
R2399 VDD.n2824 VDD.n2823 12.3591
R2400 VDD.n2736 VDD.n714 12.3591
R2401 VDD.n2716 VDD.n2715 12.3591
R2402 VDD.n2615 VDD.n2614 12.3591
R2403 VDD.n2588 VDD.n2587 12.3591
R2404 VDD.n910 VDD.n901 12.3591
R2405 VDD.n960 VDD.n937 12.3591
R2406 VDD.n1022 VDD.n1020 12.3591
R2407 VDD.n2450 VDD.n1044 12.3591
R2408 VDD.n1855 VDD.n1854 12.1761
R2409 VDD.n1791 VDD.n1787 12.1761
R2410 VDD.n2689 VDD.n760 12.1761
R2411 VDD.n2623 VDD.n2622 12.1761
R2412 VDD.n2597 VDD.n839 11.9177
R2413 VDD.n2562 VDD.n884 11.9177
R2414 VDD.n947 VDD.n945 11.9177
R2415 VDD.n2495 VDD.n2494 11.9177
R2416 VDD.n2407 VDD.n2406 11.5517
R2417 VDD.n2347 VDD.n2344 11.5517
R2418 VDD.n387 VDD.n301 11.5517
R2419 VDD.n391 VDD.n281 11.5517
R2420 VDD.n2696 VDD.n757 11.5157
R2421 VDD.n459 VDD.n266 11.4764
R2422 VDD.n240 VDD.n238 11.4764
R2423 VDD.n544 VDD.n220 11.4764
R2424 VDD.n567 VDD.n566 11.4764
R2425 VDD.n690 VDD.n689 11.4764
R2426 VDD.n1211 VDD.n1210 11.4764
R2427 VDD.n1231 VDD.n1230 11.4764
R2428 VDD.n2339 VDD.n2296 11.4764
R2429 VDD.n2335 VDD.n2334 11.4764
R2430 VDD.n2233 VDD.n2232 11.4764
R2431 VDD.n1376 VDD.n1136 11.4764
R2432 VDD.n1688 VDD.n1127 11.4764
R2433 VDD.n1726 VDD.n1121 11.4764
R2434 VDD.n1865 VDD.n1864 11.4764
R2435 VDD.n455 VDD.n271 11.4764
R2436 VDD.n501 VDD.n500 11.4764
R2437 VDD.n2870 VDD.n75 11.4764
R2438 VDD.n2845 VDD.n99 11.4764
R2439 VDD.n132 VDD.n125 11.4764
R2440 VDD.n2737 VDD.n712 11.4764
R2441 VDD.n743 VDD.n736 11.4764
R2442 VDD.n819 VDD.n812 11.4764
R2443 VDD.n1142 VDD.n851 11.4764
R2444 VDD.n2552 VDD.n2551 11.4764
R2445 VDD.n962 VDD.n961 11.4764
R2446 VDD.n2484 VDD.n995 11.4764
R2447 VDD.n2449 VDD.n1045 11.4764
R2448 VDD.t25 VDD.n2733 11.3516
R2449 VDD.n2598 VDD.n836 11.035
R2450 VDD.n2561 VDD.n885 11.035
R2451 VDD.n2534 VDD.n924 11.035
R2452 VDD.n1004 VDD.n979 11.035
R2453 VDD.n1353 VDD.n760 11.035
R2454 VDD.n2618 VDD.n2617 10.796
R2455 VDD.n1359 VDD.n809 10.796
R2456 VDD.n1371 VDD.n1370 10.796
R2457 VDD.n2605 VDD.n831 10.796
R2458 VDD.n1389 VDD.n841 10.796
R2459 VDD.n2595 VDD.n2594 10.796
R2460 VDD.n1380 VDD.n843 10.796
R2461 VDD.n2584 VDD.n854 10.796
R2462 VDD.n1558 VDD.n1140 10.796
R2463 VDD.n1141 VDD.n869 10.796
R2464 VDD.n2575 VDD.n2574 10.796
R2465 VDD.n1571 VDD.n1570 10.796
R2466 VDD.n2565 VDD.n879 10.796
R2467 VDD.n2564 VDD.n881 10.796
R2468 VDD.n895 VDD.n894 10.796
R2469 VDD.n1691 VDD.n897 10.796
R2470 VDD.n1701 VDD.n1700 10.796
R2471 VDD.n2542 VDD.n915 10.796
R2472 VDD.n2541 VDD.n917 10.796
R2473 VDD.n927 VDD.n926 10.796
R2474 VDD.n2532 VDD.n2531 10.796
R2475 VDD.n1714 VDD.n929 10.796
R2476 VDD.n2522 VDD.n939 10.796
R2477 VDD.n1722 VDD.n953 10.796
R2478 VDD.n2512 VDD.n2511 10.796
R2479 VDD.n1728 VDD.n955 10.796
R2480 VDD.n2501 VDD.n970 10.796
R2481 VDD.n982 VDD.n981 10.796
R2482 VDD.n2492 VDD.n2491 10.796
R2483 VDD.n1867 VDD.n984 10.796
R2484 VDD.n2482 VDD.n997 10.796
R2485 VDD.n2481 VDD.n999 10.796
R2486 VDD.n1013 VDD.n1012 10.796
R2487 VDD.n2472 VDD.n2471 10.796
R2488 VDD.n1745 VDD.n1015 10.796
R2489 VDD.n2463 VDD.n1028 10.796
R2490 VDD.n1846 VDD.n1845 10.6151
R2491 VDD.n1845 VDD.n1844 10.6151
R2492 VDD.n1804 VDD.n1782 10.6151
R2493 VDD.n1799 VDD.n1782 10.6151
R2494 VDD.n2377 VDD.n2271 10.6151
R2495 VDD.n355 VDD.n354 10.6151
R2496 VDD.n2683 VDD.n2682 10.6151
R2497 VDD.n2682 VDD.n782 10.6151
R2498 VDD.n2631 VDD.n798 10.6151
R2499 VDD.n2631 VDD.n2630 10.6151
R2500 VDD.n461 VDD.n460 10.5936
R2501 VDD.n486 VDD.n251 10.5936
R2502 VDD.n548 VDD.n547 10.5936
R2503 VDD.n564 VDD.n563 10.5936
R2504 VDD.n691 VDD.n204 10.5936
R2505 VDD.n2745 VDD.n706 10.5936
R2506 VDD.n1232 VDD.n1200 10.5936
R2507 VDD.n2340 VDD.n2294 10.5936
R2508 VDD.n2305 VDD.n2304 10.5936
R2509 VDD.n2234 VDD.n2230 10.5936
R2510 VDD.n1561 VDD.n1560 10.5936
R2511 VDD.n1582 VDD.n1581 10.5936
R2512 VDD.n1885 VDD.n1884 10.5936
R2513 VDD.n1869 VDD.n1866 10.5936
R2514 VDD.n454 VDD.n272 10.5936
R2515 VDD.n495 VDD.n243 10.5936
R2516 VDD.n2867 VDD.n2866 10.5936
R2517 VDD.n2849 VDD.n2848 10.5936
R2518 VDD.n2817 VDD.n133 10.5936
R2519 VDD.n2741 VDD.n2740 10.5936
R2520 VDD.n2709 VDD.n744 10.5936
R2521 VDD.n820 VDD.n818 10.5936
R2522 VDD.n1556 VDD.n1143 10.5936
R2523 VDD.n903 VDD.n900 10.5936
R2524 VDD.n2509 VDD.n958 10.5936
R2525 VDD.n2485 VDD.n988 10.5936
R2526 VDD.n2446 VDD.n2445 10.5936
R2527 VDD.n2378 VDD.n2268 10.3029
R2528 VDD.n2372 VDD.n2274 10.3029
R2529 VDD.n358 VDD.n314 10.3029
R2530 VDD.n351 VDD.n315 10.3029
R2531 VDD.n2602 VDD.n2601 10.1522
R2532 VDD.n2558 VDD.n2557 10.1522
R2533 VDD.n2535 VDD.n921 10.1522
R2534 VDD.n1006 VDD.n1005 10.1522
R2535 VDD.n1850 VDD.n1743 9.99074
R2536 VDD.n1751 VDD.n1749 9.99074
R2537 VDD.n1805 VDD.n1779 9.99074
R2538 VDD.n1798 VDD.n1785 9.99074
R2539 VDD.n781 VDD.n780 9.99074
R2540 VDD.n2679 VDD.n2678 9.99074
R2541 VDD.n2635 VDD.n2634 9.99074
R2542 VDD.n2627 VDD.n803 9.99074
R2543 VDD.n466 VDD.n263 9.71084
R2544 VDD.n490 VDD.n489 9.71084
R2545 VDD.n550 VDD.n549 9.71084
R2546 VDD.n562 VDD.n215 9.71084
R2547 VDD.n696 VDD.n694 9.71084
R2548 VDD.n2746 VDD.n705 9.71084
R2549 VDD.n1237 VDD.n1235 9.71084
R2550 VDD.n2694 VDD.n2693 9.71084
R2551 VDD.n2238 VDD.n2237 9.71084
R2552 VDD.n1137 VDD.n1132 9.71084
R2553 VDD.n1578 VDD.n1129 9.71084
R2554 VDD.n1883 VDD.n1730 9.71084
R2555 VDD.n1870 VDD.n1733 9.71084
R2556 VDD.n1856 VDD.n1855 9.71084
R2557 VDD.n470 VDD.n260 9.71084
R2558 VDD.n496 VDD.n494 9.71084
R2559 VDD.n85 VDD.n78 9.71084
R2560 VDD.n98 VDD.n97 9.71084
R2561 VDD.n2816 VDD.n134 9.71084
R2562 VDD.n711 VDD.n146 9.71084
R2563 VDD.n2708 VDD.n745 9.71084
R2564 VDD.n816 VDD.n815 9.71084
R2565 VDD.n1555 VDD.n1144 9.71084
R2566 VDD.n904 VDD.n902 9.71084
R2567 VDD.n2508 VDD.n959 9.71084
R2568 VDD.n2489 VDD.n2488 9.71084
R2569 VDD.n1055 VDD.n1048 9.71084
R2570 VDD.n2382 VDD.n2381 9.67855
R2571 VDD.n2371 VDD.n2275 9.67855
R2572 VDD.n362 VDD.n359 9.67855
R2573 VDD.n350 VDD.n316 9.67855
R2574 VDD.n2321 VDD.n2320 9.45567
R2575 VDD.n2324 VDD.n2309 9.45567
R2576 VDD.n1851 VDD.n1741 9.36635
R2577 VDD.n1839 VDD.n1753 9.36635
R2578 VDD.n1809 VDD.n1808 9.36635
R2579 VDD.n1795 VDD.n1794 9.36635
R2580 VDD.n2688 VDD.n764 9.36635
R2581 VDD.n2675 VDD.n2674 9.36635
R2582 VDD.n2638 VDD.n797 9.36635
R2583 VDD.n2626 VDD.n804 9.36635
R2584 VDD.n2685 VDD.n778 9.35656
R2585 VDD.n1727 VDD.t0 9.35656
R2586 VDD.n2046 VDD.n2045 9.30379
R2587 VDD.n394 VDD.n281 9.30173
R2588 VDD.n2320 VDD.n2319 9.3005
R2589 VDD.n2317 VDD.n2315 9.3005
R2590 VDD.n2296 VDD.n2295 9.3005
R2591 VDD.n2341 VDD.n2340 9.3005
R2592 VDD.n2343 VDD.n2342 9.3005
R2593 VDD.n2307 VDD.n2247 9.3005
R2594 VDD.n2308 VDD.n2305 9.3005
R2595 VDD.n2334 VDD.n2333 9.3005
R2596 VDD.n2332 VDD.n2331 9.3005
R2597 VDD.n2310 VDD.n2309 9.3005
R2598 VDD.n2004 VDD.n1999 9.3005
R2599 VDD.n2039 VDD.n2038 9.3005
R2600 VDD.n2037 VDD.n2036 9.3005
R2601 VDD.n2012 VDD.n2006 9.3005
R2602 VDD.n2014 VDD.n2013 9.3005
R2603 VDD.n2028 VDD.n2027 9.3005
R2604 VDD.n2026 VDD.n2025 9.3005
R2605 VDD.n2020 VDD.n2019 9.3005
R2606 VDD.n2018 VDD.n1972 9.3005
R2607 VDD.n2062 VDD.n2061 9.3005
R2608 VDD.n2060 VDD.n2059 9.3005
R2609 VDD.n1994 VDD.n1976 9.3005
R2610 VDD.n1997 VDD.n1996 9.3005
R2611 VDD.n1986 VDD.n1984 9.3005
R2612 VDD.n2050 VDD.n2049 9.3005
R2613 VDD.n1010 VDD.n1009 9.3005
R2614 VDD.n2476 VDD.n2475 9.3005
R2615 VDD.n2478 VDD.n2477 9.3005
R2616 VDD.n1008 VDD.n1002 9.3005
R2617 VDD.n1007 VDD.n1006 9.3005
R2618 VDD.n979 VDD.n978 9.3005
R2619 VDD.n2496 VDD.n2495 9.3005
R2620 VDD.n2498 VDD.n2497 9.3005
R2621 VDD.n977 VDD.n975 9.3005
R2622 VDD.n973 VDD.n950 9.3005
R2623 VDD.n2516 VDD.n2515 9.3005
R2624 VDD.n2518 VDD.n2517 9.3005
R2625 VDD.n949 VDD.n943 9.3005
R2626 VDD.n948 VDD.n947 9.3005
R2627 VDD.n924 VDD.n923 9.3005
R2628 VDD.n2536 VDD.n2535 9.3005
R2629 VDD.n2538 VDD.n2537 9.3005
R2630 VDD.n922 VDD.n920 9.3005
R2631 VDD.n1697 VDD.n1696 9.3005
R2632 VDD.n1695 VDD.n1693 9.3005
R2633 VDD.n892 VDD.n891 9.3005
R2634 VDD.n2559 VDD.n2558 9.3005
R2635 VDD.n2561 VDD.n2560 9.3005
R2636 VDD.n890 VDD.n884 9.3005
R2637 VDD.n889 VDD.n888 9.3005
R2638 VDD.n866 VDD.n864 9.3005
R2639 VDD.n2579 VDD.n2578 9.3005
R2640 VDD.n2581 VDD.n2580 9.3005
R2641 VDD.n863 VDD.n857 9.3005
R2642 VDD.n862 VDD.n861 9.3005
R2643 VDD.n839 VDD.n838 9.3005
R2644 VDD.n2599 VDD.n2598 9.3005
R2645 VDD.n2601 VDD.n2600 9.3005
R2646 VDD.n837 VDD.n835 9.3005
R2647 VDD.n1367 VDD.n1366 9.3005
R2648 VDD.n1365 VDD.n1360 9.3005
R2649 VDD.n1364 VDD.n1363 9.3005
R2650 VDD.n1948 VDD.n1947 9.3005
R2651 VDD.n1906 VDD.n1901 9.3005
R2652 VDD.n1940 VDD.n1939 9.3005
R2653 VDD.n1938 VDD.n1937 9.3005
R2654 VDD.n1914 VDD.n1908 9.3005
R2655 VDD.n1916 VDD.n1915 9.3005
R2656 VDD.n1929 VDD.n1928 9.3005
R2657 VDD.n1927 VDD.n1926 9.3005
R2658 VDD.n1921 VDD.n1919 9.3005
R2659 VDD.n1918 VDD.n1103 9.3005
R2660 VDD.n1964 VDD.n1963 9.3005
R2661 VDD.n1962 VDD.n1961 9.3005
R2662 VDD.n1892 VDD.n1891 9.3005
R2663 VDD.n1895 VDD.n1894 9.3005
R2664 VDD.n1116 VDD.n1114 9.3005
R2665 VDD.n1952 VDD.n1951 9.3005
R2666 VDD.n1679 VDD.n1678 9.3005
R2667 VDD.n1596 VDD.n1595 9.3005
R2668 VDD.n1667 VDD.n1602 9.3005
R2669 VDD.n1669 VDD.n1668 9.3005
R2670 VDD.n1665 VDD.n1664 9.3005
R2671 VDD.n1663 VDD.n1662 9.3005
R2672 VDD.n1611 VDD.n1604 9.3005
R2673 VDD.n1613 VDD.n1612 9.3005
R2674 VDD.n1653 VDD.n1614 9.3005
R2675 VDD.n1616 VDD.n1615 9.3005
R2676 VDD.n1647 VDD.n1646 9.3005
R2677 VDD.n1645 VDD.n1644 9.3005
R2678 VDD.n1629 VDD.n1619 9.3005
R2679 VDD.n1631 VDD.n1630 9.3005
R2680 VDD.n1634 VDD.n1633 9.3005
R2681 VDD.n1635 VDD.n1587 9.3005
R2682 VDD.n1550 VDD.n1148 9.3005
R2683 VDD.n1536 VDD.n1149 9.3005
R2684 VDD.n1156 VDD.n1154 9.3005
R2685 VDD.n1541 VDD.n1540 9.3005
R2686 VDD.n1164 VDD.n1157 9.3005
R2687 VDD.n1534 VDD.n1533 9.3005
R2688 VDD.n1166 VDD.n1163 9.3005
R2689 VDD.n1480 VDD.n1479 9.3005
R2690 VDD.n1524 VDD.n1481 9.3005
R2691 VDD.n1483 VDD.n1482 9.3005
R2692 VDD.n1518 VDD.n1517 9.3005
R2693 VDD.n1516 VDD.n1515 9.3005
R2694 VDD.n1495 VDD.n1494 9.3005
R2695 VDD.n1497 VDD.n1496 9.3005
R2696 VDD.n1504 VDD.n1499 9.3005
R2697 VDD.n1506 VDD.n1505 9.3005
R2698 VDD.n2154 VDD.n2153 9.3005
R2699 VDD.n2112 VDD.n2098 9.3005
R2700 VDD.n2146 VDD.n2145 9.3005
R2701 VDD.n2144 VDD.n2143 9.3005
R2702 VDD.n2120 VDD.n2114 9.3005
R2703 VDD.n2122 VDD.n2121 9.3005
R2704 VDD.n2135 VDD.n2134 9.3005
R2705 VDD.n2133 VDD.n2132 9.3005
R2706 VDD.n2127 VDD.n2125 9.3005
R2707 VDD.n2124 VDD.n2070 9.3005
R2708 VDD.n2170 VDD.n2169 9.3005
R2709 VDD.n2168 VDD.n2167 9.3005
R2710 VDD.n2093 VDD.n2074 9.3005
R2711 VDD.n2096 VDD.n2095 9.3005
R2712 VDD.n2084 VDD.n2082 9.3005
R2713 VDD.n2158 VDD.n2157 9.3005
R2714 VDD.n2433 VDD.n1063 9.3005
R2715 VDD.n1073 VDD.n1064 9.3005
R2716 VDD.n1071 VDD.n1069 9.3005
R2717 VDD.n2424 VDD.n2423 9.3005
R2718 VDD.n2179 VDD.n1072 9.3005
R2719 VDD.n2178 VDD.n2177 9.3005
R2720 VDD.n2191 VDD.n2190 9.3005
R2721 VDD.n2193 VDD.n2192 9.3005
R2722 VDD.n2198 VDD.n2196 9.3005
R2723 VDD.n2195 VDD.n1090 9.3005
R2724 VDD.n2209 VDD.n2204 9.3005
R2725 VDD.n2211 VDD.n2210 9.3005
R2726 VDD.n2207 VDD.n2206 9.3005
R2727 VDD.n2205 VDD.n1085 9.3005
R2728 VDD.n2221 VDD.n2220 9.3005
R2729 VDD.n2222 VDD.n1080 9.3005
R2730 VDD.n2292 VDD.n2241 9.3005
R2731 VDD.n2415 VDD.n2414 9.3005
R2732 VDD.n2239 VDD.n2229 9.3005
R2733 VDD.n2237 VDD.n2236 9.3005
R2734 VDD.n2235 VDD.n2234 9.3005
R2735 VDD.n2232 VDD.n2231 9.3005
R2736 VDD.n1038 VDD.n1037 9.3005
R2737 VDD.n2457 VDD.n2456 9.3005
R2738 VDD.n2459 VDD.n2458 9.3005
R2739 VDD.n1739 VDD.n1034 9.3005
R2740 VDD.n1855 VDD.n1740 9.3005
R2741 VDD.n1787 VDD.n1786 9.3005
R2742 VDD.n1796 VDD.n1795 9.3005
R2743 VDD.n1798 VDD.n1797 9.3005
R2744 VDD.n1782 VDD.n1781 9.3005
R2745 VDD.n1826 VDD.n1825 9.3005
R2746 VDD.n1828 VDD.n1827 9.3005
R2747 VDD.n1764 VDD.n1762 9.3005
R2748 VDD.n1758 VDD.n1757 9.3005
R2749 VDD.n1836 VDD.n1835 9.3005
R2750 VDD.n1838 VDD.n1837 9.3005
R2751 VDD.n1756 VDD.n1753 9.3005
R2752 VDD.n1755 VDD.n1749 9.3005
R2753 VDD.n1845 VDD.n1748 9.3005
R2754 VDD.n1854 VDD.n1853 9.3005
R2755 VDD.n1852 VDD.n1851 9.3005
R2756 VDD.n1743 VDD.n1742 9.3005
R2757 VDD.n1766 VDD.n1765 9.3005
R2758 VDD.n1772 VDD.n1770 9.3005
R2759 VDD.n1818 VDD.n1817 9.3005
R2760 VDD.n1816 VDD.n1815 9.3005
R2761 VDD.n1774 VDD.n1773 9.3005
R2762 VDD.n1780 VDD.n1778 9.3005
R2763 VDD.n1808 VDD.n1807 9.3005
R2764 VDD.n1806 VDD.n1805 9.3005
R2765 VDD.n1791 VDD.n1790 9.3005
R2766 VDD.n1857 VDD.n1737 9.3005
R2767 VDD.n1862 VDD.n1861 9.3005
R2768 VDD.n1864 VDD.n1863 9.3005
R2769 VDD.n1866 VDD.n1735 9.3005
R2770 VDD.n1871 VDD.n1870 9.3005
R2771 VDD.n1873 VDD.n1872 9.3005
R2772 VDD.n1734 VDD.n1732 9.3005
R2773 VDD.n1878 VDD.n1731 9.3005
R2774 VDD.n1881 VDD.n1880 9.3005
R2775 VDD.n1883 VDD.n1882 9.3005
R2776 VDD.n1886 VDD.n1885 9.3005
R2777 VDD.n1121 VDD.n1120 9.3005
R2778 VDD.n1720 VDD.n1719 9.3005
R2779 VDD.n1718 VDD.n1717 9.3005
R2780 VDD.n1713 VDD.n1123 9.3005
R2781 VDD.n1711 VDD.n1708 9.3005
R2782 VDD.n1707 VDD.n1706 9.3005
R2783 VDD.n1704 VDD.n1125 9.3005
R2784 VDD.n1584 VDD.n1126 9.3005
R2785 VDD.n1688 VDD.n1687 9.3005
R2786 VDD.n1583 VDD.n1582 9.3005
R2787 VDD.n1129 VDD.n1128 9.3005
R2788 VDD.n1577 VDD.n1576 9.3005
R2789 VDD.n1575 VDD.n1574 9.3005
R2790 VDD.n1569 VDD.n1131 9.3005
R2791 VDD.n1567 VDD.n1566 9.3005
R2792 VDD.n1137 VDD.n1133 9.3005
R2793 VDD.n1562 VDD.n1561 9.3005
R2794 VDD.n1376 VDD.n1135 9.3005
R2795 VDD.n1378 VDD.n1375 9.3005
R2796 VDD.n1384 VDD.n1383 9.3005
R2797 VDD.n1386 VDD.n1385 9.3005
R2798 VDD.n1392 VDD.n1351 9.3005
R2799 VDD.n1395 VDD.n1394 9.3005
R2800 VDD.n1353 VDD.n762 9.3005
R2801 VDD.n1352 VDD.n1350 9.3005
R2802 VDD.n1356 VDD.n1355 9.3005
R2803 VDD.n1455 VDD.n1454 9.3005
R2804 VDD.n1410 VDD.n1409 9.3005
R2805 VDD.n1443 VDD.n1416 9.3005
R2806 VDD.n1445 VDD.n1444 9.3005
R2807 VDD.n1441 VDD.n1440 9.3005
R2808 VDD.n1439 VDD.n1438 9.3005
R2809 VDD.n1428 VDD.n1418 9.3005
R2810 VDD.n1430 VDD.n1429 9.3005
R2811 VDD.n1425 VDD.n1423 9.3005
R2812 VDD.n1422 VDD.n1332 9.3005
R2813 VDD.n1471 VDD.n1470 9.3005
R2814 VDD.n1469 VDD.n1468 9.3005
R2815 VDD.n1404 VDD.n1336 9.3005
R2816 VDD.n1407 VDD.n1406 9.3005
R2817 VDD.n1346 VDD.n1344 9.3005
R2818 VDD.n1459 VDD.n1458 9.3005
R2819 VDD.n1308 VDD.n1307 9.3005
R2820 VDD.n1262 VDD.n1261 9.3005
R2821 VDD.n1296 VDD.n1268 9.3005
R2822 VDD.n1298 VDD.n1297 9.3005
R2823 VDD.n1294 VDD.n1293 9.3005
R2824 VDD.n1292 VDD.n1291 9.3005
R2825 VDD.n1281 VDD.n1270 9.3005
R2826 VDD.n1283 VDD.n1282 9.3005
R2827 VDD.n1278 VDD.n1274 9.3005
R2828 VDD.n1276 VDD.n1275 9.3005
R2829 VDD.n1324 VDD.n1323 9.3005
R2830 VDD.n1322 VDD.n1321 9.3005
R2831 VDD.n1256 VDD.n1181 9.3005
R2832 VDD.n1259 VDD.n1258 9.3005
R2833 VDD.n1191 VDD.n1189 9.3005
R2834 VDD.n1312 VDD.n1311 9.3005
R2835 VDD.n2800 VDD.n151 9.3005
R2836 VDD.n2786 VDD.n152 9.3005
R2837 VDD.n159 VDD.n157 9.3005
R2838 VDD.n2791 VDD.n2790 9.3005
R2839 VDD.n167 VDD.n160 9.3005
R2840 VDD.n2784 VDD.n2783 9.3005
R2841 VDD.n169 VDD.n166 9.3005
R2842 VDD.n178 VDD.n177 9.3005
R2843 VDD.n2774 VDD.n179 9.3005
R2844 VDD.n181 VDD.n180 9.3005
R2845 VDD.n2768 VDD.n2767 9.3005
R2846 VDD.n2766 VDD.n2765 9.3005
R2847 VDD.n193 VDD.n184 9.3005
R2848 VDD.n195 VDD.n194 9.3005
R2849 VDD.n2754 VDD.n197 9.3005
R2850 VDD.n2756 VDD.n2755 9.3005
R2851 VDD.n665 VDD.n664 9.3005
R2852 VDD.n585 VDD.n580 9.3005
R2853 VDD.n657 VDD.n656 9.3005
R2854 VDD.n655 VDD.n654 9.3005
R2855 VDD.n593 VDD.n587 9.3005
R2856 VDD.n595 VDD.n594 9.3005
R2857 VDD.n646 VDD.n645 9.3005
R2858 VDD.n644 VDD.n643 9.3005
R2859 VDD.n635 VDD.n600 9.3005
R2860 VDD.n637 VDD.n636 9.3005
R2861 VDD.n607 VDD.n602 9.3005
R2862 VDD.n609 VDD.n608 9.3005
R2863 VDD.n626 VDD.n625 9.3005
R2864 VDD.n624 VDD.n623 9.3005
R2865 VDD.n612 VDD.n611 9.3005
R2866 VDD.n613 VDD.n572 9.3005
R2867 VDD.n2927 VDD.n2926 9.3005
R2868 VDD.n2885 VDD.n58 9.3005
R2869 VDD.n2919 VDD.n2918 9.3005
R2870 VDD.n2917 VDD.n2916 9.3005
R2871 VDD.n2893 VDD.n2887 9.3005
R2872 VDD.n2895 VDD.n2894 9.3005
R2873 VDD.n2908 VDD.n2907 9.3005
R2874 VDD.n2906 VDD.n2905 9.3005
R2875 VDD.n2900 VDD.n2898 9.3005
R2876 VDD.n2897 VDD.n33 9.3005
R2877 VDD.n2943 VDD.n2942 9.3005
R2878 VDD.n2941 VDD.n2940 9.3005
R2879 VDD.n49 VDD.n37 9.3005
R2880 VDD.n52 VDD.n51 9.3005
R2881 VDD.n47 VDD.n45 9.3005
R2882 VDD.n2931 VDD.n2930 9.3005
R2883 VDD.n2976 VDD.n2975 9.3005
R2884 VDD.n17 VDD.n11 9.3005
R2885 VDD.n2968 VDD.n2967 9.3005
R2886 VDD.n2966 VDD.n2965 9.3005
R2887 VDD.n2954 VDD.n19 9.3005
R2888 VDD.n2956 VDD.n2955 9.3005
R2889 VDD.n2957 VDD.n2 9.3005
R2890 VDD.n2980 VDD.n2979 9.3005
R2891 VDD.n405 VDD.n3 9.3005
R2892 VDD.n409 VDD.n408 9.3005
R2893 VDD.n414 VDD.n413 9.3005
R2894 VDD.n412 VDD.n403 9.3005
R2895 VDD.n422 VDD.n421 9.3005
R2896 VDD.n424 VDD.n423 9.3005
R2897 VDD.n428 VDD.n427 9.3005
R2898 VDD.n426 VDD.n398 9.3005
R2899 VDD.n303 VDD.n274 9.3005
R2900 VDD.n450 VDD.n449 9.3005
R2901 VDD.n452 VDD.n271 9.3005
R2902 VDD.n454 VDD.n453 9.3005
R2903 VDD.n260 VDD.n259 9.3005
R2904 VDD.n473 VDD.n472 9.3005
R2905 VDD.n474 VDD.n257 9.3005
R2906 VDD.n476 VDD.n475 9.3005
R2907 VDD.n246 VDD.n245 9.3005
R2908 VDD.n497 VDD.n496 9.3005
R2909 VDD.n498 VDD.n243 9.3005
R2910 VDD.n500 VDD.n499 9.3005
R2911 VDD.n230 VDD.n229 9.3005
R2912 VDD.n527 VDD.n526 9.3005
R2913 VDD.n529 VDD.n528 9.3005
R2914 VDD.n531 VDD.n61 9.3005
R2915 VDD.n2879 VDD.n2878 9.3005
R2916 VDD.n64 VDD.n62 9.3005
R2917 VDD.n76 VDD.n74 9.3005
R2918 VDD.n2870 VDD.n2869 9.3005
R2919 VDD.n2868 VDD.n2867 9.3005
R2920 VDD.n78 VDD.n77 9.3005
R2921 VDD.n88 VDD.n86 9.3005
R2922 VDD.n2859 VDD.n2858 9.3005
R2923 VDD.n2857 VDD.n2856 9.3005
R2924 VDD.n90 VDD.n89 9.3005
R2925 VDD.n100 VDD.n98 9.3005
R2926 VDD.n2848 VDD.n2847 9.3005
R2927 VDD.n2846 VDD.n2845 9.3005
R2928 VDD.n112 VDD.n102 9.3005
R2929 VDD.n113 VDD.n110 9.3005
R2930 VDD.n2837 VDD.n2836 9.3005
R2931 VDD.n2835 VDD.n2834 9.3005
R2932 VDD.n122 VDD.n114 9.3005
R2933 VDD.n2827 VDD.n2826 9.3005
R2934 VDD.n2825 VDD.n2824 9.3005
R2935 VDD.n125 VDD.n124 9.3005
R2936 VDD.n135 VDD.n133 9.3005
R2937 VDD.n2816 VDD.n2815 9.3005
R2938 VDD.n2814 VDD.n2813 9.3005
R2939 VDD.n137 VDD.n136 9.3005
R2940 VDD.n147 VDD.n145 9.3005
R2941 VDD.n2805 VDD.n2804 9.3005
R2942 VDD.n711 VDD.n149 9.3005
R2943 VDD.n2740 VDD.n2739 9.3005
R2944 VDD.n2738 VDD.n2737 9.3005
R2945 VDD.n714 VDD.n713 9.3005
R2946 VDD.n724 VDD.n722 9.3005
R2947 VDD.n2729 VDD.n2728 9.3005
R2948 VDD.n2727 VDD.n2726 9.3005
R2949 VDD.n733 VDD.n725 9.3005
R2950 VDD.n2719 VDD.n2718 9.3005
R2951 VDD.n2717 VDD.n2716 9.3005
R2952 VDD.n736 VDD.n735 9.3005
R2953 VDD.n746 VDD.n744 9.3005
R2954 VDD.n2708 VDD.n2707 9.3005
R2955 VDD.n1239 VDD.n747 9.3005
R2956 VDD.n2703 VDD.n749 9.3005
R2957 VDD.n2702 VDD.n2701 9.3005
R2958 VDD.n752 VDD.n750 9.3005
R2959 VDD.n816 VDD.n814 9.3005
R2960 VDD.n821 VDD.n820 9.3005
R2961 VDD.n822 VDD.n812 9.3005
R2962 VDD.n2614 VDD.n2613 9.3005
R2963 VDD.n826 VDD.n823 9.3005
R2964 VDD.n2609 VDD.n2608 9.3005
R2965 VDD.n828 VDD.n825 9.3005
R2966 VDD.n849 VDD.n847 9.3005
R2967 VDD.n2591 VDD.n2590 9.3005
R2968 VDD.n2589 VDD.n2588 9.3005
R2969 VDD.n851 VDD.n850 9.3005
R2970 VDD.n1145 VDD.n1143 9.3005
R2971 VDD.n1555 VDD.n1554 9.3005
R2972 VDD.n875 VDD.n873 9.3005
R2973 VDD.n2571 VDD.n2570 9.3005
R2974 VDD.n2569 VDD.n2568 9.3005
R2975 VDD.n877 VDD.n876 9.3005
R2976 VDD.n905 VDD.n904 9.3005
R2977 VDD.n906 VDD.n900 9.3005
R2978 VDD.n2551 VDD.n2550 9.3005
R2979 VDD.n910 VDD.n907 9.3005
R2980 VDD.n2546 VDD.n2545 9.3005
R2981 VDD.n912 VDD.n909 9.3005
R2982 VDD.n935 VDD.n933 9.3005
R2983 VDD.n2528 VDD.n2527 9.3005
R2984 VDD.n2526 VDD.n2525 9.3005
R2985 VDD.n937 VDD.n936 9.3005
R2986 VDD.n963 VDD.n962 9.3005
R2987 VDD.n964 VDD.n958 9.3005
R2988 VDD.n2508 VDD.n2507 9.3005
R2989 VDD.n2506 VDD.n2505 9.3005
R2990 VDD.n967 VDD.n966 9.3005
R2991 VDD.n992 VDD.n991 9.3005
R2992 VDD.n993 VDD.n987 9.3005
R2993 VDD.n2488 VDD.n2487 9.3005
R2994 VDD.n2486 VDD.n2485 9.3005
R2995 VDD.n995 VDD.n994 9.3005
R2996 VDD.n1023 VDD.n1022 9.3005
R2997 VDD.n1024 VDD.n1018 9.3005
R2998 VDD.n2468 VDD.n2467 9.3005
R2999 VDD.n2466 VDD.n2465 9.3005
R3000 VDD.n2101 VDD.n2100 9.3005
R3001 VDD.n2106 VDD.n2105 9.3005
R3002 VDD.n1046 VDD.n1044 9.3005
R3003 VDD.n2449 VDD.n2448 9.3005
R3004 VDD.n2447 VDD.n2446 9.3005
R3005 VDD.n1048 VDD.n1047 9.3005
R3006 VDD.n1058 VDD.n1056 9.3005
R3007 VDD.n2246 VDD.n1060 9.3005
R3008 VDD.n2438 VDD.n2437 9.3005
R3009 VDD.n2407 VDD.n2248 9.3005
R3010 VDD.n2285 VDD.n2284 9.3005
R3011 VDD.n2359 VDD.n2358 9.3005
R3012 VDD.n2361 VDD.n2360 9.3005
R3013 VDD.n2283 VDD.n2281 9.3005
R3014 VDD.n2277 VDD.n2276 9.3005
R3015 VDD.n2369 VDD.n2368 9.3005
R3016 VDD.n2371 VDD.n2370 9.3005
R3017 VDD.n2274 VDD.n2270 9.3005
R3018 VDD.n2401 VDD.n2400 9.3005
R3019 VDD.n2253 VDD.n2249 9.3005
R3020 VDD.n2399 VDD.n2398 9.3005
R3021 VDD.n2255 VDD.n2254 9.3005
R3022 VDD.n2261 VDD.n2259 9.3005
R3023 VDD.n2391 VDD.n2390 9.3005
R3024 VDD.n2389 VDD.n2388 9.3005
R3025 VDD.n2263 VDD.n2262 9.3005
R3026 VDD.n2269 VDD.n2267 9.3005
R3027 VDD.n2381 VDD.n2380 9.3005
R3028 VDD.n2379 VDD.n2378 9.3005
R3029 VDD.n2291 VDD.n2289 9.3005
R3030 VDD.n2351 VDD.n2350 9.3005
R3031 VDD.n2349 VDD.n2348 9.3005
R3032 VDD.n2344 VDD.n2293 9.3005
R3033 VDD.n2691 VDD.n760 9.3005
R3034 VDD.n2690 VDD.n2689 9.3005
R3035 VDD.n764 VDD.n763 9.3005
R3036 VDD.n783 VDD.n781 9.3005
R3037 VDD.n2682 VDD.n2681 9.3005
R3038 VDD.n2680 VDD.n2679 9.3005
R3039 VDD.n2675 VDD.n784 9.3005
R3040 VDD.n787 VDD.n785 9.3005
R3041 VDD.n2670 VDD.n2669 9.3005
R3042 VDD.n2668 VDD.n2667 9.3005
R3043 VDD.n2663 VDD.n788 9.3005
R3044 VDD.n791 VDD.n789 9.3005
R3045 VDD.n2658 VDD.n2657 9.3005
R3046 VDD.n2656 VDD.n2655 9.3005
R3047 VDD.n2651 VDD.n792 9.3005
R3048 VDD.n795 VDD.n793 9.3005
R3049 VDD.n2646 VDD.n2645 9.3005
R3050 VDD.n2644 VDD.n2643 9.3005
R3051 VDD.n2639 VDD.n796 9.3005
R3052 VDD.n799 VDD.n797 9.3005
R3053 VDD.n2634 VDD.n2633 9.3005
R3054 VDD.n2632 VDD.n2631 9.3005
R3055 VDD.n803 VDD.n800 9.3005
R3056 VDD.n2626 VDD.n2625 9.3005
R3057 VDD.n2624 VDD.n2623 9.3005
R3058 VDD.n2622 VDD.n805 9.3005
R3059 VDD.n2693 VDD.n2692 9.3005
R3060 VDD.n761 VDD.n759 9.3005
R3061 VDD.n1199 VDD.n1196 9.3005
R3062 VDD.n1247 VDD.n1246 9.3005
R3063 VDD.n1236 VDD.n1195 9.3005
R3064 VDD.n1235 VDD.n1234 9.3005
R3065 VDD.n1233 VDD.n1232 9.3005
R3066 VDD.n1230 VDD.n1201 9.3005
R3067 VDD.n1228 VDD.n1227 9.3005
R3068 VDD.n1226 VDD.n1225 9.3005
R3069 VDD.n1223 VDD.n1204 9.3005
R3070 VDD.n1221 VDD.n1220 9.3005
R3071 VDD.n1219 VDD.n1218 9.3005
R3072 VDD.n1216 VDD.n1207 9.3005
R3073 VDD.n1214 VDD.n1213 9.3005
R3074 VDD.n1212 VDD.n1211 9.3005
R3075 VDD.n1209 VDD.n706 9.3005
R3076 VDD.n2747 VDD.n2746 9.3005
R3077 VDD.n704 VDD.n201 9.3005
R3078 VDD.n702 VDD.n701 9.3005
R3079 VDD.n700 VDD.n699 9.3005
R3080 VDD.n697 VDD.n203 9.3005
R3081 VDD.n694 VDD.n693 9.3005
R3082 VDD.n692 VDD.n691 9.3005
R3083 VDD.n689 VDD.n205 9.3005
R3084 VDD.n687 VDD.n686 9.3005
R3085 VDD.n685 VDD.n684 9.3005
R3086 VDD.n682 VDD.n208 9.3005
R3087 VDD.n680 VDD.n679 9.3005
R3088 VDD.n678 VDD.n677 9.3005
R3089 VDD.n675 VDD.n211 9.3005
R3090 VDD.n673 VDD.n672 9.3005
R3091 VDD.n568 VDD.n567 9.3005
R3092 VDD.n564 VDD.n214 9.3005
R3093 VDD.n562 VDD.n561 9.3005
R3094 VDD.n560 VDD.n559 9.3005
R3095 VDD.n557 VDD.n216 9.3005
R3096 VDD.n554 VDD.n553 9.3005
R3097 VDD.n552 VDD.n551 9.3005
R3098 VDD.n549 VDD.n218 9.3005
R3099 VDD.n547 VDD.n546 9.3005
R3100 VDD.n545 VDD.n544 9.3005
R3101 VDD.n542 VDD.n221 9.3005
R3102 VDD.n540 VDD.n539 9.3005
R3103 VDD.n538 VDD.n537 9.3005
R3104 VDD.n512 VDD.n224 9.3005
R3105 VDD.n519 VDD.n518 9.3005
R3106 VDD.n510 VDD.n235 9.3005
R3107 VDD.n509 VDD.n508 9.3005
R3108 VDD.n238 VDD.n237 9.3005
R3109 VDD.n487 VDD.n486 9.3005
R3110 VDD.n489 VDD.n488 9.3005
R3111 VDD.n485 VDD.n250 9.3005
R3112 VDD.n484 VDD.n483 9.3005
R3113 VDD.n253 VDD.n252 9.3005
R3114 VDD.n465 VDD.n464 9.3005
R3115 VDD.n463 VDD.n263 9.3005
R3116 VDD.n462 VDD.n461 9.3005
R3117 VDD.n266 VDD.n265 9.3005
R3118 VDD.n442 VDD.n441 9.3005
R3119 VDD.n395 VDD.n278 9.3005
R3120 VDD.n304 VDD.n301 9.3005
R3121 VDD.n386 VDD.n385 9.3005
R3122 VDD.n384 VDD.n383 9.3005
R3123 VDD.n307 VDD.n306 9.3005
R3124 VDD.n378 VDD.n377 9.3005
R3125 VDD.n376 VDD.n375 9.3005
R3126 VDD.n371 VDD.n309 9.3005
R3127 VDD.n312 VDD.n310 9.3005
R3128 VDD.n366 VDD.n365 9.3005
R3129 VDD.n364 VDD.n363 9.3005
R3130 VDD.n359 VDD.n313 9.3005
R3131 VDD.n317 VDD.n314 9.3005
R3132 VDD.n318 VDD.n315 9.3005
R3133 VDD.n350 VDD.n349 9.3005
R3134 VDD.n348 VDD.n347 9.3005
R3135 VDD.n343 VDD.n319 9.3005
R3136 VDD.n322 VDD.n320 9.3005
R3137 VDD.n338 VDD.n337 9.3005
R3138 VDD.n336 VDD.n335 9.3005
R3139 VDD.n331 VDD.n323 9.3005
R3140 VDD.n325 VDD.n324 9.3005
R3141 VDD.n326 VDD.n282 9.3005
R3142 VDD.n393 VDD.n392 9.3005
R3143 VDD.n1361 VDD.n835 9.26947
R3144 VDD.n1692 VDD.n892 9.26947
R3145 VDD.n2539 VDD.n2538 9.26947
R3146 VDD.n2479 VDD.n1002 9.26947
R3147 VDD.n1390 VDD.t19 9.11666
R3148 VDD.n2267 VDD.n2265 9.05416
R3149 VDD.n2368 VDD.n2367 9.05416
R3150 VDD.n363 VDD.n311 9.05416
R3151 VDD.n347 VDD.n346 9.05416
R3152 VDD.n465 VDD.n264 8.82809
R3153 VDD.n482 VDD.n250 8.82809
R3154 VDD.n551 VDD.n217 8.82809
R3155 VDD.n559 VDD.n558 8.82809
R3156 VDD.n698 VDD.n697 8.82809
R3157 VDD.n704 VDD.n703 8.82809
R3158 VDD.n1236 VDD.n1197 8.82809
R3159 VDD.n1198 VDD.n759 8.82809
R3160 VDD.n2240 VDD.n2239 8.82809
R3161 VDD.n1568 VDD.n1567 8.82809
R3162 VDD.n1577 VDD.n1130 8.82809
R3163 VDD.n1880 VDD.n1879 8.82809
R3164 VDD.n1874 VDD.n1873 8.82809
R3165 VDD.n472 VDD.n471 8.82809
R3166 VDD.n258 VDD.n246 8.82809
R3167 VDD.n2860 VDD.n86 8.82809
R3168 VDD.n2855 VDD.n90 8.82809
R3169 VDD.n2813 VDD.n2812 8.82809
R3170 VDD.n2806 VDD.n2805 8.82809
R3171 VDD.n1240 VDD.n1239 8.82809
R3172 VDD.n2700 VDD.n752 8.82809
R3173 VDD.n2572 VDD.n873 8.82809
R3174 VDD.n2567 VDD.n877 8.82809
R3175 VDD.n2505 VDD.n2504 8.82809
R3176 VDD.n990 VDD.n987 8.82809
R3177 VDD.n2439 VDD.n1056 8.82809
R3178 VDD.n1838 VDD.n1754 8.74196
R3179 VDD.n1778 VDD.n1776 8.74196
R3180 VDD.n2671 VDD.n785 8.74196
R3181 VDD.n2642 VDD.n2639 8.74196
R3182 VDD.n2387 VDD.n2263 8.42977
R3183 VDD.n2279 VDD.n2277 8.42977
R3184 VDD.n367 VDD.n366 8.42977
R3185 VDD.n343 VDD.n342 8.42977
R3186 VDD.n1379 VDD.t3 8.39697
R3187 VDD.n1363 VDD.n1362 8.38671
R3188 VDD.n1368 VDD.n1367 8.38671
R3189 VDD.n1698 VDD.n1693 8.38671
R3190 VDD.n1694 VDD.n920 8.38671
R3191 VDD.n2478 VDD.n1003 8.38671
R3192 VDD.n2474 VDD.n1010 8.38671
R3193 VDD.n1723 VDD.t1 8.15707
R3194 VDD.n1835 VDD.n1834 8.11757
R3195 VDD.n1814 VDD.n1774 8.11757
R3196 VDD.n2670 VDD.n786 8.11757
R3197 VDD.n2643 VDD.n794 8.11757
R3198 VDD.n481 VDD.n253 7.94533
R3199 VDD.n483 VDD.n481 7.94533
R3200 VDD.n556 VDD.n554 7.94533
R3201 VDD.n557 VDD.n556 7.94533
R3202 VDD.n699 VDD.n202 7.94533
R3203 VDD.n702 VDD.n202 7.94533
R3204 VDD.n1246 VDD.n1245 7.94533
R3205 VDD.n1245 VDD.n1199 7.94533
R3206 VDD.n2414 VDD.n2413 7.94533
R3207 VDD.n2413 VDD.n2241 7.94533
R3208 VDD.n1573 VDD.n1569 7.94533
R3209 VDD.n1574 VDD.n1573 7.94533
R3210 VDD.n1878 VDD.n1877 7.94533
R3211 VDD.n1877 VDD.n1732 7.94533
R3212 VDD.n477 VDD.n257 7.94533
R3213 VDD.n477 VDD.n476 7.94533
R3214 VDD.n2859 VDD.n87 7.94533
R3215 VDD.n2856 VDD.n87 7.94533
R3216 VDD.n144 VDD.n137 7.94533
R3217 VDD.n145 VDD.n144 7.94533
R3218 VDD.n751 VDD.n749 7.94533
R3219 VDD.n2701 VDD.n751 7.94533
R3220 VDD.n2571 VDD.n874 7.94533
R3221 VDD.n2568 VDD.n874 7.94533
R3222 VDD.n989 VDD.n967 7.94533
R3223 VDD.n991 VDD.n989 7.94533
R3224 VDD.n2438 VDD.n1057 7.94533
R3225 VDD.n2246 VDD.n1057 7.94533
R3226 VDD.n1949 VDD.t11 7.8805
R3227 VDD.n1949 VDD.t31 7.8805
R3228 VDD.n1680 VDD.t21 7.8805
R3229 VDD.n1680 VDD.t20 7.8805
R3230 VDD.n1538 VDD.t29 7.8805
R3231 VDD.n1538 VDD.t6 7.8805
R3232 VDD.n2788 VDD.t28 7.8805
R3233 VDD.n2788 VDD.t26 7.8805
R3234 VDD.n666 VDD.t10 7.8805
R3235 VDD.n666 VDD.t24 7.8805
R3236 VDD.n2928 VDD.t8 7.8805
R3237 VDD.n2928 VDD.t5 7.8805
R3238 VDD.t27 VDD.n130 7.85896
R3239 VDD.n2388 VDD.n2260 7.80538
R3240 VDD.n2362 VDD.n2281 7.80538
R3241 VDD.n370 VDD.n310 7.80538
R3242 VDD.n339 VDD.n320 7.80538
R3243 VDD.n1362 VDD.n1360 7.50395
R3244 VDD.n1368 VDD.n1360 7.50395
R3245 VDD.n1698 VDD.n1697 7.50395
R3246 VDD.n1697 VDD.n1694 7.50395
R3247 VDD.n2475 VDD.n1003 7.50395
R3248 VDD.n2475 VDD.n2474 7.50395
R3249 VDD.n1760 VDD.n1758 7.49318
R3250 VDD.n1815 VDD.n1771 7.49318
R3251 VDD.n2667 VDD.n2666 7.49318
R3252 VDD.n2647 VDD.n2646 7.49318
R3253 VDD.n2392 VDD.n2391 7.18099
R3254 VDD.n2361 VDD.n2282 7.18099
R3255 VDD.n374 VDD.n371 7.18099
R3256 VDD.n338 VDD.n321 7.18099
R3257 VDD.n264 VDD.n253 7.06257
R3258 VDD.n483 VDD.n482 7.06257
R3259 VDD.n554 VDD.n217 7.06257
R3260 VDD.n558 VDD.n557 7.06257
R3261 VDD.n699 VDD.n698 7.06257
R3262 VDD.n703 VDD.n702 7.06257
R3263 VDD.n1246 VDD.n1197 7.06257
R3264 VDD.n1199 VDD.n1198 7.06257
R3265 VDD.n2414 VDD.n2240 7.06257
R3266 VDD.n2243 VDD.n2241 7.06257
R3267 VDD.n1569 VDD.n1568 7.06257
R3268 VDD.n1574 VDD.n1130 7.06257
R3269 VDD.n1879 VDD.n1878 7.06257
R3270 VDD.n1874 VDD.n1732 7.06257
R3271 VDD.n471 VDD.n257 7.06257
R3272 VDD.n476 VDD.n258 7.06257
R3273 VDD.n2860 VDD.n2859 7.06257
R3274 VDD.n2856 VDD.n2855 7.06257
R3275 VDD.n2812 VDD.n137 7.06257
R3276 VDD.n2806 VDD.n145 7.06257
R3277 VDD.n1240 VDD.n749 7.06257
R3278 VDD.n2701 VDD.n2700 7.06257
R3279 VDD.n2572 VDD.n2571 7.06257
R3280 VDD.n2568 VDD.n2567 7.06257
R3281 VDD.n2504 VDD.n967 7.06257
R3282 VDD.n991 VDD.n990 7.06257
R3283 VDD.n2439 VDD.n2438 7.06257
R3284 VDD.n2408 VDD.n2246 7.06257
R3285 VDD.n1829 VDD.n1762 6.86879
R3286 VDD.n1819 VDD.n1818 6.86879
R3287 VDD.n2663 VDD.n2662 6.86879
R3288 VDD.n2650 VDD.n793 6.86879
R3289 VDD.n1363 VDD.n806 6.62119
R3290 VDD.n1367 VDD.n1361 6.62119
R3291 VDD.n1693 VDD.n1692 6.62119
R3292 VDD.n2539 VDD.n920 6.62119
R3293 VDD.n2479 VDD.n2478 6.62119
R3294 VDD.n1789 VDD.n1010 6.62119
R3295 VDD.n2402 VDD.n2249 6.5566
R3296 VDD.n2259 VDD.n2257 6.5566
R3297 VDD.n2358 VDD.n2357 6.5566
R3298 VDD.n2348 VDD.n2290 6.5566
R3299 VDD.n386 VDD.n302 6.5566
R3300 VDD.n375 VDD.n308 6.5566
R3301 VDD.n335 VDD.n334 6.5566
R3302 VDD.n392 VDD.n283 6.5566
R3303 VDD.n1828 VDD.n1763 6.2444
R3304 VDD.n1770 VDD.n1768 6.2444
R3305 VDD.n2659 VDD.n789 6.2444
R3306 VDD.n2654 VDD.n2651 6.2444
R3307 VDD.n2463 VDD.n2462 6.23787
R3308 VDD.n466 VDD.n465 6.17981
R3309 VDD.n490 VDD.n250 6.17981
R3310 VDD.n551 VDD.n550 6.17981
R3311 VDD.n559 VDD.n215 6.17981
R3312 VDD.n697 VDD.n696 6.17981
R3313 VDD.n705 VDD.n704 6.17981
R3314 VDD.n1237 VDD.n1236 6.17981
R3315 VDD.n2694 VDD.n759 6.17981
R3316 VDD.n2239 VDD.n2238 6.17981
R3317 VDD.n1567 VDD.n1132 6.17981
R3318 VDD.n1578 VDD.n1577 6.17981
R3319 VDD.n1880 VDD.n1730 6.17981
R3320 VDD.n1873 VDD.n1733 6.17981
R3321 VDD.n472 VDD.n470 6.17981
R3322 VDD.n494 VDD.n246 6.17981
R3323 VDD.n86 VDD.n85 6.17981
R3324 VDD.n97 VDD.n90 6.17981
R3325 VDD.n2813 VDD.n134 6.17981
R3326 VDD.n2805 VDD.n146 6.17981
R3327 VDD.n1239 VDD.n745 6.17981
R3328 VDD.n815 VDD.n752 6.17981
R3329 VDD.n1144 VDD.n873 6.17981
R3330 VDD.n902 VDD.n877 6.17981
R3331 VDD.n2505 VDD.n959 6.17981
R3332 VDD.n2489 VDD.n987 6.17981
R3333 VDD.n1056 VDD.n1055 6.17981
R3334 VDD.n2874 VDD.t4 6.11263
R3335 VDD.n2401 VDD.n2251 5.93221
R3336 VDD.n2397 VDD.n2255 5.93221
R3337 VDD.n2287 VDD.n2285 5.93221
R3338 VDD.n2352 VDD.n2351 5.93221
R3339 VDD.n383 VDD.n382 5.93221
R3340 VDD.n379 VDD.n378 5.93221
R3341 VDD.n331 VDD.n330 5.93221
R3342 VDD.n327 VDD.n326 5.93221
R3343 VDD.n2602 VDD.n835 5.73843
R3344 VDD.n2557 VDD.n892 5.73843
R3345 VDD.n2538 VDD.n921 5.73843
R3346 VDD.n1005 VDD.n1002 5.73843
R3347 VDD.n2344 VDD.n2243 5.73843
R3348 VDD.n2408 VDD.n2407 5.73843
R3349 VDD.n1825 VDD.n1824 5.62001
R3350 VDD.n1824 VDD.n1766 5.62001
R3351 VDD.n2658 VDD.n790 5.62001
R3352 VDD.n2655 VDD.n790 5.62001
R3353 VDD.n766 VDD.n757 5.51818
R3354 VDD.n2618 VDD.n778 5.51818
R3355 VDD.n2617 VDD.n809 5.51818
R3356 VDD.n1370 VDD.n1359 5.51818
R3357 VDD.n1371 VDD.n831 5.51818
R3358 VDD.n2605 VDD.n2604 5.51818
R3359 VDD.n1390 VDD.n1389 5.51818
R3360 VDD.n2595 VDD.n841 5.51818
R3361 VDD.n2594 VDD.n843 5.51818
R3362 VDD.n1380 VDD.n1379 5.51818
R3363 VDD.n2585 VDD.n2584 5.51818
R3364 VDD.n1140 VDD.n854 5.51818
R3365 VDD.n1558 VDD.n1141 5.51818
R3366 VDD.n2575 VDD.n869 5.51818
R3367 VDD.n1571 VDD.n879 5.51818
R3368 VDD.n2565 VDD.n2564 5.51818
R3369 VDD.n894 VDD.n881 5.51818
R3370 VDD.n2555 VDD.n895 5.51818
R3371 VDD.n2555 VDD.t18 5.51818
R3372 VDD.n2554 VDD.n897 5.51818
R3373 VDD.n1700 VDD.n1691 5.51818
R3374 VDD.n1701 VDD.n915 5.51818
R3375 VDD.n2542 VDD.n2541 5.51818
R3376 VDD.n2532 VDD.n927 5.51818
R3377 VDD.n2531 VDD.n929 5.51818
R3378 VDD.n1714 VDD.n939 5.51818
R3379 VDD.n2522 VDD.n2521 5.51818
R3380 VDD.n1723 VDD.n1722 5.51818
R3381 VDD.n2512 VDD.n953 5.51818
R3382 VDD.n2511 VDD.n955 5.51818
R3383 VDD.n1728 VDD.n1727 5.51818
R3384 VDD.n2502 VDD.n2501 5.51818
R3385 VDD.n981 VDD.n970 5.51818
R3386 VDD.n2492 VDD.n982 5.51818
R3387 VDD.n2491 VDD.n984 5.51818
R3388 VDD.n2482 VDD.n2481 5.51818
R3389 VDD.n1012 VDD.n999 5.51818
R3390 VDD.n2472 VDD.n1013 5.51818
R3391 VDD.n2471 VDD.n1015 5.51818
R3392 VDD.n2398 VDD.n2251 5.30782
R3393 VDD.n2398 VDD.n2397 5.30782
R3394 VDD.n2289 VDD.n2287 5.30782
R3395 VDD.n2352 VDD.n2289 5.30782
R3396 VDD.n382 VDD.n307 5.30782
R3397 VDD.n379 VDD.n307 5.30782
R3398 VDD.n330 VDD.n325 5.30782
R3399 VDD.n327 VDD.n325 5.30782
R3400 VDD.n460 VDD.n263 5.29705
R3401 VDD.n489 VDD.n251 5.29705
R3402 VDD.n549 VDD.n548 5.29705
R3403 VDD.n563 VDD.n562 5.29705
R3404 VDD.n694 VDD.n204 5.29705
R3405 VDD.n2746 VDD.n2745 5.29705
R3406 VDD.n1235 VDD.n1200 5.29705
R3407 VDD.n2343 VDD.n2294 5.29705
R3408 VDD.n2304 VDD.n2247 5.29705
R3409 VDD.n2237 VDD.n2230 5.29705
R3410 VDD.n1560 VDD.n1137 5.29705
R3411 VDD.n1581 VDD.n1129 5.29705
R3412 VDD.n1884 VDD.n1883 5.29705
R3413 VDD.n1870 VDD.n1869 5.29705
R3414 VDD.n272 VDD.n260 5.29705
R3415 VDD.n496 VDD.n495 5.29705
R3416 VDD.n2866 VDD.n78 5.29705
R3417 VDD.n2849 VDD.n98 5.29705
R3418 VDD.n2817 VDD.n2816 5.29705
R3419 VDD.n2741 VDD.n711 5.29705
R3420 VDD.n2709 VDD.n2708 5.29705
R3421 VDD.n818 VDD.n816 5.29705
R3422 VDD.n1556 VDD.n1555 5.29705
R3423 VDD.n904 VDD.n903 5.29705
R3424 VDD.n2509 VDD.n2508 5.29705
R3425 VDD.n2488 VDD.n988 5.29705
R3426 VDD.n2445 VDD.n1048 5.29705
R3427 VDD.t18 VDD.n2554 5.27828
R3428 VDD.n1867 VDD.t16 5.27828
R3429 VDD.n1825 VDD.n1763 4.99562
R3430 VDD.n1768 VDD.n1766 4.99562
R3431 VDD.n2659 VDD.n2658 4.99562
R3432 VDD.n2655 VDD.n2654 4.99562
R3433 VDD.n281 VDD.n280 4.85567
R3434 VDD.n2601 VDD.n836 4.85567
R3435 VDD.n2558 VDD.n885 4.85567
R3436 VDD.n2535 VDD.n2534 4.85567
R3437 VDD.n1006 VDD.n1004 4.85567
R3438 VDD.n301 VDD.n300 4.85567
R3439 VDD.n2047 VDD.t30 4.7285
R3440 VDD.n2155 VDD.t33 4.7285
R3441 VDD.n2421 VDD.t15 4.7285
R3442 VDD.n1456 VDD.t22 4.7285
R3443 VDD.n1309 VDD.t13 4.7285
R3444 VDD.n2977 VDD.t35 4.7285
R3445 VDD.n2402 VDD.n2401 4.68343
R3446 VDD.n2257 VDD.n2255 4.68343
R3447 VDD.n2357 VDD.n2285 4.68343
R3448 VDD.n2351 VDD.n2290 4.68343
R3449 VDD.n383 VDD.n302 4.68343
R3450 VDD.n378 VDD.n308 4.68343
R3451 VDD.n334 VDD.n331 4.68343
R3452 VDD.n326 VDD.n283 4.68343
R3453 VDD.n2622 VDD.n806 4.63498
R3454 VDD.n1791 VDD.n1789 4.63498
R3455 VDD.n304 VDD.n13 4.60277
R3456 VDD.n671 VDD.n670 4.53459
R3457 VDD.n2749 VDD.n199 4.53459
R3458 VDD.n1989 VDD.n1988 4.53011
R3459 VDD.n516 VDD.n223 4.52702
R3460 VDD.n516 VDD.n511 4.52702
R3461 VDD.n2435 VDD.n1059 4.52702
R3462 VDD.n2435 VDD.n1061 4.52702
R3463 VDD.n2045 VDD.n2044 4.52682
R3464 VDD.n670 VDD.n569 4.51944
R3465 VDD.n2749 VDD.n200 4.51944
R3466 VDD.n440 VDD.n439 4.51186
R3467 VDD.n1987 VDD.n1985 4.5005
R3468 VDD.n2052 VDD.n2051 4.5005
R3469 VDD.n1995 VDD.n1980 4.5005
R3470 VDD.n2056 VDD.n1979 4.5005
R3471 VDD.n2058 VDD.n2057 4.5005
R3472 VDD.n1977 VDD.n1973 4.5005
R3473 VDD.n2064 VDD.n2063 4.5005
R3474 VDD.n2016 VDD.n1970 4.5005
R3475 VDD.n2017 VDD.n1969 4.5005
R3476 VDD.n2024 VDD.n2023 4.5005
R3477 VDD.n2021 VDD.n2015 4.5005
R3478 VDD.n2030 VDD.n2029 4.5005
R3479 VDD.n2011 VDD.n2008 4.5005
R3480 VDD.n2035 VDD.n2034 4.5005
R3481 VDD.n2007 VDD.n2005 4.5005
R3482 VDD.n2041 VDD.n2040 4.5005
R3483 VDD.n2001 VDD.n2000 4.5005
R3484 VDD.n1117 VDD.n1115 4.5005
R3485 VDD.n1954 VDD.n1953 4.5005
R3486 VDD.n1893 VDD.n1110 4.5005
R3487 VDD.n1958 VDD.n1109 4.5005
R3488 VDD.n1960 VDD.n1959 4.5005
R3489 VDD.n1107 VDD.n1104 4.5005
R3490 VDD.n1966 VDD.n1965 4.5005
R3491 VDD.n1920 VDD.n1101 4.5005
R3492 VDD.n1921 VDD.n1100 4.5005
R3493 VDD.n1925 VDD.n1924 4.5005
R3494 VDD.n1922 VDD.n1917 4.5005
R3495 VDD.n1931 VDD.n1930 4.5005
R3496 VDD.n1913 VDD.n1910 4.5005
R3497 VDD.n1936 VDD.n1935 4.5005
R3498 VDD.n1909 VDD.n1907 4.5005
R3499 VDD.n1942 VDD.n1941 4.5005
R3500 VDD.n1903 VDD.n1902 4.5005
R3501 VDD.n1947 VDD.n1946 4.5005
R3502 VDD.n1890 VDD.n1889 4.5005
R3503 VDD.n1627 VDD.n1586 4.5005
R3504 VDD.n1637 VDD.n1636 4.5005
R3505 VDD.n1632 VDD.n1623 4.5005
R3506 VDD.n1641 VDD.n1622 4.5005
R3507 VDD.n1643 VDD.n1642 4.5005
R3508 VDD.n1620 VDD.n1618 4.5005
R3509 VDD.n1649 VDD.n1648 4.5005
R3510 VDD.n1652 VDD.n1651 4.5005
R3511 VDD.n1653 VDD.n1609 4.5005
R3512 VDD.n1655 VDD.n1654 4.5005
R3513 VDD.n1610 VDD.n1607 4.5005
R3514 VDD.n1661 VDD.n1660 4.5005
R3515 VDD.n1605 VDD.n1603 4.5005
R3516 VDD.n1666 VDD.n1600 4.5005
R3517 VDD.n1671 VDD.n1670 4.5005
R3518 VDD.n1601 VDD.n1598 4.5005
R3519 VDD.n1677 VDD.n1676 4.5005
R3520 VDD.n1678 VDD.n908 4.5005
R3521 VDD.n1683 VDD.n1682 4.5005
R3522 VDD.n1503 VDD.n1502 4.5005
R3523 VDD.n1508 VDD.n1507 4.5005
R3524 VDD.n1498 VDD.n1489 4.5005
R3525 VDD.n1512 VDD.n1488 4.5005
R3526 VDD.n1514 VDD.n1513 4.5005
R3527 VDD.n1486 VDD.n1485 4.5005
R3528 VDD.n1520 VDD.n1519 4.5005
R3529 VDD.n1523 VDD.n1522 4.5005
R3530 VDD.n1524 VDD.n1477 4.5005
R3531 VDD.n1526 VDD.n1525 4.5005
R3532 VDD.n1478 VDD.n1169 4.5005
R3533 VDD.n1532 VDD.n1531 4.5005
R3534 VDD.n1167 VDD.n1165 4.5005
R3535 VDD.n1155 VDD.n1152 4.5005
R3536 VDD.n1543 VDD.n1542 4.5005
R3537 VDD.n1153 VDD.n1150 4.5005
R3538 VDD.n1549 VDD.n1548 4.5005
R3539 VDD.n1551 VDD.n1550 4.5005
R3540 VDD.n1500 VDD.n1134 4.5005
R3541 VDD.n1564 VDD.n1563 4.5005
R3542 VDD.n1565 VDD.n1564 4.5005
R3543 VDD.n1686 VDD.n1685 4.5005
R3544 VDD.n1685 VDD.n1684 4.5005
R3545 VDD.n1888 VDD.n1887 4.5005
R3546 VDD.n1888 VDD.n1119 4.5005
R3547 VDD.n2085 VDD.n2083 4.5005
R3548 VDD.n2160 VDD.n2159 4.5005
R3549 VDD.n2094 VDD.n2078 4.5005
R3550 VDD.n2164 VDD.n2077 4.5005
R3551 VDD.n2166 VDD.n2165 4.5005
R3552 VDD.n2075 VDD.n2071 4.5005
R3553 VDD.n2172 VDD.n2171 4.5005
R3554 VDD.n2126 VDD.n2068 4.5005
R3555 VDD.n2127 VDD.n2067 4.5005
R3556 VDD.n2131 VDD.n2130 4.5005
R3557 VDD.n2128 VDD.n2123 4.5005
R3558 VDD.n2137 VDD.n2136 4.5005
R3559 VDD.n2119 VDD.n2116 4.5005
R3560 VDD.n2142 VDD.n2141 4.5005
R3561 VDD.n2115 VDD.n2113 4.5005
R3562 VDD.n2148 VDD.n2147 4.5005
R3563 VDD.n2109 VDD.n2099 4.5005
R3564 VDD.n2153 VDD.n2152 4.5005
R3565 VDD.n2088 VDD.n2087 4.5005
R3566 VDD.n1082 VDD.n1081 4.5005
R3567 VDD.n2224 VDD.n2223 4.5005
R3568 VDD.n2219 VDD.n2218 4.5005
R3569 VDD.n2217 VDD.n1087 4.5005
R3570 VDD.n2208 VDD.n1086 4.5005
R3571 VDD.n2213 VDD.n2212 4.5005
R3572 VDD.n2203 VDD.n2202 4.5005
R3573 VDD.n2197 VDD.n1091 4.5005
R3574 VDD.n2199 VDD.n2198 4.5005
R3575 VDD.n2194 VDD.n2175 4.5005
R3576 VDD.n2184 VDD.n2176 4.5005
R3577 VDD.n2189 VDD.n2188 4.5005
R3578 VDD.n2181 VDD.n2180 4.5005
R3579 VDD.n1070 VDD.n1067 4.5005
R3580 VDD.n2426 VDD.n2425 4.5005
R3581 VDD.n1068 VDD.n1065 4.5005
R3582 VDD.n2432 VDD.n2431 4.5005
R3583 VDD.n2434 VDD.n2433 4.5005
R3584 VDD.n2419 VDD.n2418 4.5005
R3585 VDD.n2417 VDD.n2416 4.5005
R3586 VDD.n2417 VDD.n2228 4.5005
R3587 VDD.n1347 VDD.n1345 4.5005
R3588 VDD.n1461 VDD.n1460 4.5005
R3589 VDD.n1405 VDD.n1340 4.5005
R3590 VDD.n1465 VDD.n1339 4.5005
R3591 VDD.n1467 VDD.n1466 4.5005
R3592 VDD.n1337 VDD.n1335 4.5005
R3593 VDD.n1473 VDD.n1472 4.5005
R3594 VDD.n1424 VDD.n1330 4.5005
R3595 VDD.n1425 VDD.n1329 4.5005
R3596 VDD.n1427 VDD.n1426 4.5005
R3597 VDD.n1432 VDD.n1431 4.5005
R3598 VDD.n1437 VDD.n1436 4.5005
R3599 VDD.n1419 VDD.n1417 4.5005
R3600 VDD.n1442 VDD.n1414 4.5005
R3601 VDD.n1447 VDD.n1446 4.5005
R3602 VDD.n1415 VDD.n1412 4.5005
R3603 VDD.n1453 VDD.n1452 4.5005
R3604 VDD.n1454 VDD.n824 4.5005
R3605 VDD.n1399 VDD.n1398 4.5005
R3606 VDD.n1397 VDD.n1349 4.5005
R3607 VDD.n1397 VDD.n1396 4.5005
R3608 VDD.n1192 VDD.n1190 4.5005
R3609 VDD.n1314 VDD.n1313 4.5005
R3610 VDD.n1257 VDD.n1185 4.5005
R3611 VDD.n1318 VDD.n1184 4.5005
R3612 VDD.n1320 VDD.n1319 4.5005
R3613 VDD.n1182 VDD.n1178 4.5005
R3614 VDD.n1326 VDD.n1325 4.5005
R3615 VDD.n1277 VDD.n1176 4.5005
R3616 VDD.n1278 VDD.n1175 4.5005
R3617 VDD.n1280 VDD.n1279 4.5005
R3618 VDD.n1285 VDD.n1284 4.5005
R3619 VDD.n1290 VDD.n1289 4.5005
R3620 VDD.n1271 VDD.n1269 4.5005
R3621 VDD.n1295 VDD.n1266 4.5005
R3622 VDD.n1300 VDD.n1299 4.5005
R3623 VDD.n1267 VDD.n1264 4.5005
R3624 VDD.n1306 VDD.n1305 4.5005
R3625 VDD.n1307 VDD.n748 4.5005
R3626 VDD.n1251 VDD.n1250 4.5005
R3627 VDD.n2753 VDD.n2752 4.5005
R3628 VDD.n2758 VDD.n2757 4.5005
R3629 VDD.n196 VDD.n188 4.5005
R3630 VDD.n2762 VDD.n187 4.5005
R3631 VDD.n2764 VDD.n2763 4.5005
R3632 VDD.n185 VDD.n183 4.5005
R3633 VDD.n2770 VDD.n2769 4.5005
R3634 VDD.n2773 VDD.n2772 4.5005
R3635 VDD.n2774 VDD.n175 4.5005
R3636 VDD.n2776 VDD.n2775 4.5005
R3637 VDD.n176 VDD.n172 4.5005
R3638 VDD.n2782 VDD.n2781 4.5005
R3639 VDD.n170 VDD.n168 4.5005
R3640 VDD.n158 VDD.n155 4.5005
R3641 VDD.n2793 VDD.n2792 4.5005
R3642 VDD.n156 VDD.n153 4.5005
R3643 VDD.n2799 VDD.n2798 4.5005
R3644 VDD.n2801 VDD.n2800 4.5005
R3645 VDD.n2750 VDD.n198 4.5005
R3646 VDD.n616 VDD.n571 4.5005
R3647 VDD.n615 VDD.n614 4.5005
R3648 VDD.n622 VDD.n621 4.5005
R3649 VDD.n610 VDD.n605 4.5005
R3650 VDD.n628 VDD.n627 4.5005
R3651 VDD.n606 VDD.n603 4.5005
R3652 VDD.n634 VDD.n633 4.5005
R3653 VDD.n639 VDD.n638 4.5005
R3654 VDD.n640 VDD.n600 4.5005
R3655 VDD.n642 VDD.n641 4.5005
R3656 VDD.n597 VDD.n596 4.5005
R3657 VDD.n648 VDD.n647 4.5005
R3658 VDD.n592 VDD.n589 4.5005
R3659 VDD.n653 VDD.n652 4.5005
R3660 VDD.n588 VDD.n586 4.5005
R3661 VDD.n659 VDD.n658 4.5005
R3662 VDD.n582 VDD.n581 4.5005
R3663 VDD.n664 VDD.n663 4.5005
R3664 VDD.n669 VDD.n668 4.5005
R3665 VDD.n513 VDD.n46 4.5005
R3666 VDD.n2933 VDD.n2932 4.5005
R3667 VDD.n50 VDD.n41 4.5005
R3668 VDD.n2937 VDD.n40 4.5005
R3669 VDD.n2939 VDD.n2938 4.5005
R3670 VDD.n38 VDD.n34 4.5005
R3671 VDD.n2945 VDD.n2944 4.5005
R3672 VDD.n2899 VDD.n31 4.5005
R3673 VDD.n2900 VDD.n29 4.5005
R3674 VDD.n2904 VDD.n2903 4.5005
R3675 VDD.n2901 VDD.n2896 4.5005
R3676 VDD.n2910 VDD.n2909 4.5005
R3677 VDD.n2892 VDD.n2889 4.5005
R3678 VDD.n2915 VDD.n2914 4.5005
R3679 VDD.n2888 VDD.n2886 4.5005
R3680 VDD.n2921 VDD.n2920 4.5005
R3681 VDD.n2882 VDD.n59 4.5005
R3682 VDD.n2926 VDD.n2925 4.5005
R3683 VDD.n515 VDD.n48 4.5005
R3684 VDD.n436 VDD.n435 4.5005
R3685 VDD.n425 VDD.n399 4.5005
R3686 VDD.n430 VDD.n429 4.5005
R3687 VDD.n402 VDD.n401 4.5005
R3688 VDD.n420 VDD.n419 4.5005
R3689 VDD.n416 VDD.n415 4.5005
R3690 VDD.n411 VDD.n410 4.5005
R3691 VDD.n407 VDD.n406 4.5005
R3692 VDD.n405 VDD.n26 4.5005
R3693 VDD.n23 VDD.n1 4.5005
R3694 VDD.n2951 VDD.n0 4.5005
R3695 VDD.n2959 VDD.n2958 4.5005
R3696 VDD.n2953 VDD.n21 4.5005
R3697 VDD.n2964 VDD.n2963 4.5005
R3698 VDD.n20 VDD.n18 4.5005
R3699 VDD.n2970 VDD.n2969 4.5005
R3700 VDD.n14 VDD.n12 4.5005
R3701 VDD.n2975 VDD.n2974 4.5005
R3702 VDD.n438 VDD.n437 4.5005
R3703 VDD.n273 VDD.n13 4.5005
R3704 VDD.n451 VDD.n13 4.5005
R3705 VDD.n2881 VDD.n60 4.5005
R3706 VDD.n2881 VDD.n2880 4.5005
R3707 VDD.n2802 VDD.n148 4.5005
R3708 VDD.n2803 VDD.n2802 4.5005
R3709 VDD.n2706 VDD.n2705 4.5005
R3710 VDD.n2705 VDD.n2704 4.5005
R3711 VDD.n2612 VDD.n2611 4.5005
R3712 VDD.n2611 VDD.n2610 4.5005
R3713 VDD.n1552 VDD.n1146 4.5005
R3714 VDD.n1553 VDD.n1552 4.5005
R3715 VDD.n2549 VDD.n2548 4.5005
R3716 VDD.n2548 VDD.n2547 4.5005
R3717 VDD.n2108 VDD.n1025 4.5005
R3718 VDD.n2108 VDD.n2107 4.5005
R3719 VDD.n2436 VDD.n2435 4.5005
R3720 VDD.n1249 VDD.n1194 4.5005
R3721 VDD.n1249 VDD.n1248 4.5005
R3722 VDD.n2749 VDD.n2748 4.5005
R3723 VDD.n670 VDD.n213 4.5005
R3724 VDD.n517 VDD.n516 4.5005
R3725 VDD.n461 VDD.n459 4.41429
R3726 VDD.n486 VDD.n240 4.41429
R3727 VDD.n547 VDD.n220 4.41429
R3728 VDD.n566 VDD.n564 4.41429
R3729 VDD.n691 VDD.n690 4.41429
R3730 VDD.n1210 VDD.n706 4.41429
R3731 VDD.n1232 VDD.n1231 4.41429
R3732 VDD.n2340 VDD.n2339 4.41429
R3733 VDD.n2335 VDD.n2305 4.41429
R3734 VDD.n2234 VDD.n2233 4.41429
R3735 VDD.n1561 VDD.n1136 4.41429
R3736 VDD.n1582 VDD.n1127 4.41429
R3737 VDD.n1885 VDD.n1726 4.41429
R3738 VDD.n1866 VDD.n1865 4.41429
R3739 VDD.n455 VDD.n454 4.41429
R3740 VDD.n501 VDD.n243 4.41429
R3741 VDD.n2867 VDD.n75 4.41429
R3742 VDD.n2848 VDD.n99 4.41429
R3743 VDD.n133 VDD.n132 4.41429
R3744 VDD.n2740 VDD.n712 4.41429
R3745 VDD.n744 VDD.n743 4.41429
R3746 VDD.n820 VDD.n819 4.41429
R3747 VDD.n1143 VDD.n1142 4.41429
R3748 VDD.n2552 VDD.n900 4.41429
R3749 VDD.n961 VDD.n958 4.41429
R3750 VDD.n2485 VDD.n2484 4.41429
R3751 VDD.n2446 VDD.n1045 4.41429
R3752 VDD.n1829 VDD.n1828 4.37123
R3753 VDD.n1819 VDD.n1770 4.37123
R3754 VDD.n2662 VDD.n789 4.37123
R3755 VDD.n2651 VDD.n2650 4.37123
R3756 VDD.t7 VDD.n233 4.36631
R3757 VDD.n2574 VDD.t2 4.31868
R3758 VDD.n926 VDD.t17 4.07878
R3759 VDD.n1746 VDD.n1745 4.07878
R3760 VDD.n2406 VDD.n2249 4.05904
R3761 VDD.n2392 VDD.n2259 4.05904
R3762 VDD.n2358 VDD.n2282 4.05904
R3763 VDD.n2348 VDD.n2347 4.05904
R3764 VDD.n387 VDD.n386 4.05904
R3765 VDD.n375 VDD.n374 4.05904
R3766 VDD.n335 VDD.n321 4.05904
R3767 VDD.n392 VDD.n391 4.05904
R3768 VDD.n2598 VDD.n2597 3.97291
R3769 VDD.n2562 VDD.n2561 3.97291
R3770 VDD.n945 VDD.n924 3.97291
R3771 VDD.n2494 VDD.n979 3.97291
R3772 VDD.n1762 VDD.n1760 3.74684
R3773 VDD.n1818 VDD.n1771 3.74684
R3774 VDD.n2666 VDD.n2663 3.74684
R3775 VDD.n2647 VDD.n793 3.74684
R3776 VDD.n279 VDD.n266 3.53153
R3777 VDD.n506 VDD.n238 3.53153
R3778 VDD.n544 VDD.n543 3.53153
R3779 VDD.n567 VDD.n212 3.53153
R3780 VDD.n689 VDD.n688 3.53153
R3781 VDD.n1211 VDD.n1208 3.53153
R3782 VDD.n1230 VDD.n1229 3.53153
R3783 VDD.n2316 VDD.n2296 3.53153
R3784 VDD.n2334 VDD.n2306 3.53153
R3785 VDD.n2232 VDD.n1040 3.53153
R3786 VDD.n1354 VDD.n1353 3.53153
R3787 VDD.n1377 VDD.n1376 3.53153
R3788 VDD.n1689 VDD.n1688 3.53153
R3789 VDD.n1721 VDD.n1121 3.53153
R3790 VDD.n1864 VDD.n1736 3.53153
R3791 VDD.n448 VDD.n271 3.53153
R3792 VDD.n500 VDD.n244 3.53153
R3793 VDD.n2871 VDD.n2870 3.53153
R3794 VDD.n2845 VDD.n2844 3.53153
R3795 VDD.n2823 VDD.n125 3.53153
R3796 VDD.n2737 VDD.n2736 3.53153
R3797 VDD.n2715 VDD.n736 3.53153
R3798 VDD.n2615 VDD.n812 3.53153
R3799 VDD.n2587 VDD.n851 3.53153
R3800 VDD.n2551 VDD.n901 3.53153
R3801 VDD.n962 VDD.n960 3.53153
R3802 VDD.n1020 VDD.n995 3.53153
R3803 VDD.n2450 VDD.n2449 3.53153
R3804 VDD.t14 VDD.n2442 3.51576
R3805 VDD.n433 VDD.n397 3.45997
R3806 VDD.n1988 VDD.n1982 3.45997
R3807 VDD.n2044 VDD.n2043 3.45997
R3808 VDD.n1118 VDD.n1112 3.45997
R3809 VDD.n1945 VDD.n1944 3.45997
R3810 VDD.n1626 VDD.n1585 3.45997
R3811 VDD.n1674 VDD.n1597 3.45997
R3812 VDD.n1501 VDD.n1492 3.45997
R3813 VDD.n1546 VDD.n1147 3.45997
R3814 VDD.n2086 VDD.n2080 3.45997
R3815 VDD.n2151 VDD.n2150 3.45997
R3816 VDD.n2227 VDD.n2226 3.45997
R3817 VDD.n2429 VDD.n1062 3.45997
R3818 VDD.n1348 VDD.n1342 3.45997
R3819 VDD.n1450 VDD.n1411 3.45997
R3820 VDD.n1193 VDD.n1187 3.45997
R3821 VDD.n1303 VDD.n1263 3.45997
R3822 VDD.n2751 VDD.n191 3.45997
R3823 VDD.n2796 VDD.n150 3.45997
R3824 VDD.n618 VDD.n570 3.45997
R3825 VDD.n662 VDD.n661 3.45997
R3826 VDD.n514 VDD.n43 3.45997
R3827 VDD.n2924 VDD.n2923 3.45997
R3828 VDD.n2973 VDD.n2972 3.45997
R3829 VDD.n2391 VDD.n2260 3.43465
R3830 VDD.n2362 VDD.n2361 3.43465
R3831 VDD.n371 VDD.n370 3.43465
R3832 VDD.n339 VDD.n338 3.43465
R3833 VDD.n2043 VDD.n2042 3.4105
R3834 VDD.n2003 VDD.n2002 3.4105
R3835 VDD.n2034 VDD.n2033 3.4105
R3836 VDD.n2032 VDD.n2031 3.4105
R3837 VDD.n2010 VDD.n2009 3.4105
R3838 VDD.n2022 VDD.n1096 3.4105
R3839 VDD.n1971 VDD.n1095 3.4105
R3840 VDD.n1981 VDD.n1978 3.4105
R3841 VDD.n2056 VDD.n2055 3.4105
R3842 VDD.n2054 VDD.n2053 3.4105
R3843 VDD.n1983 VDD.n1982 3.4105
R3844 VDD.n1944 VDD.n1943 3.4105
R3845 VDD.n1905 VDD.n1904 3.4105
R3846 VDD.n1935 VDD.n1934 3.4105
R3847 VDD.n1933 VDD.n1932 3.4105
R3848 VDD.n1912 VDD.n1911 3.4105
R3849 VDD.n1923 VDD.n1098 3.4105
R3850 VDD.n1102 VDD.n1097 3.4105
R3851 VDD.n1111 VDD.n1108 3.4105
R3852 VDD.n1958 VDD.n1957 3.4105
R3853 VDD.n1956 VDD.n1955 3.4105
R3854 VDD.n1113 VDD.n1112 3.4105
R3855 VDD.n1675 VDD.n1674 3.4105
R3856 VDD.n1673 VDD.n1672 3.4105
R3857 VDD.n1600 VDD.n1599 3.4105
R3858 VDD.n1608 VDD.n1606 3.4105
R3859 VDD.n1659 VDD.n1658 3.4105
R3860 VDD.n1657 VDD.n1656 3.4105
R3861 VDD.n1624 VDD.n1617 3.4105
R3862 VDD.n1625 VDD.n1621 3.4105
R3863 VDD.n1641 VDD.n1640 3.4105
R3864 VDD.n1639 VDD.n1638 3.4105
R3865 VDD.n1628 VDD.n1626 3.4105
R3866 VDD.n1547 VDD.n1546 3.4105
R3867 VDD.n1545 VDD.n1544 3.4105
R3868 VDD.n1152 VDD.n1151 3.4105
R3869 VDD.n1170 VDD.n1168 3.4105
R3870 VDD.n1530 VDD.n1529 3.4105
R3871 VDD.n1528 VDD.n1527 3.4105
R3872 VDD.n1490 VDD.n1484 3.4105
R3873 VDD.n1491 VDD.n1487 3.4105
R3874 VDD.n1512 VDD.n1511 3.4105
R3875 VDD.n1510 VDD.n1509 3.4105
R3876 VDD.n1493 VDD.n1492 3.4105
R3877 VDD.n2150 VDD.n2149 3.4105
R3878 VDD.n2111 VDD.n2110 3.4105
R3879 VDD.n2141 VDD.n2140 3.4105
R3880 VDD.n2139 VDD.n2138 3.4105
R3881 VDD.n2118 VDD.n2117 3.4105
R3882 VDD.n2129 VDD.n1094 3.4105
R3883 VDD.n2069 VDD.n1093 3.4105
R3884 VDD.n2079 VDD.n2076 3.4105
R3885 VDD.n2164 VDD.n2163 3.4105
R3886 VDD.n2162 VDD.n2161 3.4105
R3887 VDD.n2081 VDD.n2080 3.4105
R3888 VDD.n2430 VDD.n2429 3.4105
R3889 VDD.n2428 VDD.n2427 3.4105
R3890 VDD.n1067 VDD.n1066 3.4105
R3891 VDD.n2185 VDD.n2182 3.4105
R3892 VDD.n2187 VDD.n2186 3.4105
R3893 VDD.n2183 VDD.n1092 3.4105
R3894 VDD.n1089 VDD.n1088 3.4105
R3895 VDD.n2215 VDD.n2214 3.4105
R3896 VDD.n2217 VDD.n2216 3.4105
R3897 VDD.n1084 VDD.n1083 3.4105
R3898 VDD.n2226 VDD.n2225 3.4105
R3899 VDD.n1451 VDD.n1450 3.4105
R3900 VDD.n1449 VDD.n1448 3.4105
R3901 VDD.n1414 VDD.n1413 3.4105
R3902 VDD.n1433 VDD.n1420 3.4105
R3903 VDD.n1435 VDD.n1434 3.4105
R3904 VDD.n1421 VDD.n1172 3.4105
R3905 VDD.n1331 VDD.n1171 3.4105
R3906 VDD.n1341 VDD.n1338 3.4105
R3907 VDD.n1465 VDD.n1464 3.4105
R3908 VDD.n1463 VDD.n1462 3.4105
R3909 VDD.n1343 VDD.n1342 3.4105
R3910 VDD.n1304 VDD.n1303 3.4105
R3911 VDD.n1302 VDD.n1301 3.4105
R3912 VDD.n1266 VDD.n1265 3.4105
R3913 VDD.n1286 VDD.n1272 3.4105
R3914 VDD.n1288 VDD.n1287 3.4105
R3915 VDD.n1273 VDD.n1174 3.4105
R3916 VDD.n1177 VDD.n1173 3.4105
R3917 VDD.n1186 VDD.n1183 3.4105
R3918 VDD.n1318 VDD.n1317 3.4105
R3919 VDD.n1316 VDD.n1315 3.4105
R3920 VDD.n1188 VDD.n1187 3.4105
R3921 VDD.n2797 VDD.n2796 3.4105
R3922 VDD.n2795 VDD.n2794 3.4105
R3923 VDD.n155 VDD.n154 3.4105
R3924 VDD.n173 VDD.n171 3.4105
R3925 VDD.n2780 VDD.n2779 3.4105
R3926 VDD.n2778 VDD.n2777 3.4105
R3927 VDD.n189 VDD.n182 3.4105
R3928 VDD.n190 VDD.n186 3.4105
R3929 VDD.n2762 VDD.n2761 3.4105
R3930 VDD.n2760 VDD.n2759 3.4105
R3931 VDD.n192 VDD.n191 3.4105
R3932 VDD.n661 VDD.n660 3.4105
R3933 VDD.n584 VDD.n583 3.4105
R3934 VDD.n652 VDD.n651 3.4105
R3935 VDD.n650 VDD.n649 3.4105
R3936 VDD.n591 VDD.n590 3.4105
R3937 VDD.n599 VDD.n598 3.4105
R3938 VDD.n632 VDD.n631 3.4105
R3939 VDD.n630 VDD.n629 3.4105
R3940 VDD.n605 VDD.n604 3.4105
R3941 VDD.n620 VDD.n619 3.4105
R3942 VDD.n618 VDD.n617 3.4105
R3943 VDD.n2923 VDD.n2922 3.4105
R3944 VDD.n2884 VDD.n2883 3.4105
R3945 VDD.n2914 VDD.n2913 3.4105
R3946 VDD.n2912 VDD.n2911 3.4105
R3947 VDD.n2891 VDD.n2890 3.4105
R3948 VDD.n2902 VDD.n28 3.4105
R3949 VDD.n32 VDD.n27 3.4105
R3950 VDD.n42 VDD.n39 3.4105
R3951 VDD.n2937 VDD.n2936 3.4105
R3952 VDD.n2935 VDD.n2934 3.4105
R3953 VDD.n44 VDD.n43 3.4105
R3954 VDD.n2947 VDD.n29 3.4105
R3955 VDD.n2947 VDD.n2946 3.4105
R3956 VDD.n640 VDD.n30 3.4105
R3957 VDD.n601 VDD.n30 3.4105
R3958 VDD.n175 VDD.n174 3.4105
R3959 VDD.n2771 VDD.n174 3.4105
R3960 VDD.n1328 VDD.n1175 3.4105
R3961 VDD.n1328 VDD.n1327 3.4105
R3962 VDD.n1475 VDD.n1329 3.4105
R3963 VDD.n1475 VDD.n1474 3.4105
R3964 VDD.n1477 VDD.n1476 3.4105
R3965 VDD.n1521 VDD.n1476 3.4105
R3966 VDD.n1609 VDD.n1099 3.4105
R3967 VDD.n1650 VDD.n1099 3.4105
R3968 VDD.n1968 VDD.n1100 3.4105
R3969 VDD.n1968 VDD.n1967 3.4105
R3970 VDD.n2066 VDD.n1969 3.4105
R3971 VDD.n2066 VDD.n2065 3.4105
R3972 VDD.n2174 VDD.n2067 3.4105
R3973 VDD.n2174 VDD.n2173 3.4105
R3974 VDD.n2200 VDD.n2199 3.4105
R3975 VDD.n2201 VDD.n2200 3.4105
R3976 VDD.n2972 VDD.n2971 3.4105
R3977 VDD.n16 VDD.n15 3.4105
R3978 VDD.n2963 VDD.n2962 3.4105
R3979 VDD.n2961 VDD.n2960 3.4105
R3980 VDD.n2952 VDD.n22 3.4105
R3981 VDD.n2950 VDD.n2949 3.4105
R3982 VDD.n2948 VDD.n26 3.4105
R3983 VDD.n2948 VDD.n25 3.4105
R3984 VDD.n404 VDD.n24 3.4105
R3985 VDD.n418 VDD.n417 3.4105
R3986 VDD.n401 VDD.n400 3.4105
R3987 VDD.n432 VDD.n431 3.4105
R3988 VDD.n434 VDD.n433 3.4105
R3989 VDD.n1834 VDD.n1758 3.12245
R3990 VDD.n1815 VDD.n1814 3.12245
R3991 VDD.n2667 VDD.n786 3.12245
R3992 VDD.n2646 VDD.n794 3.12245
R3993 VDD.n859 VDD.n839 3.09016
R3994 VDD.n887 VDD.n884 3.09016
R3995 VDD.n947 VDD.n946 3.09016
R3996 VDD.n2495 VDD.n976 3.09016
R3997 VDD.n2388 VDD.n2387 2.81026
R3998 VDD.n2281 VDD.n2279 2.81026
R3999 VDD.n367 VDD.n310 2.81026
R4000 VDD.n342 VDD.n320 2.81026
R4001 VDD.n443 VDD.n442 2.64878
R4002 VDD.n508 VDD.n507 2.64878
R4003 VDD.n542 VDD.n541 2.64878
R4004 VDD.n674 VDD.n673 2.64878
R4005 VDD.n687 VDD.n207 2.64878
R4006 VDD.n1215 VDD.n1214 2.64878
R4007 VDD.n1228 VDD.n1203 2.64878
R4008 VDD.n2693 VDD.n760 2.64878
R4009 VDD.n2318 VDD.n2317 2.64878
R4010 VDD.n2331 VDD.n2330 2.64878
R4011 VDD.n2455 VDD.n1038 2.64878
R4012 VDD.n1357 VDD.n1356 2.64878
R4013 VDD.n1382 VDD.n1378 2.64878
R4014 VDD.n1703 VDD.n1126 2.64878
R4015 VDD.n1720 VDD.n1122 2.64878
R4016 VDD.n1861 VDD.n1860 2.64878
R4017 VDD.n449 VDD.n447 2.64878
R4018 VDD.n525 VDD.n230 2.64878
R4019 VDD.n74 VDD.n73 2.64878
R4020 VDD.n109 VDD.n102 2.64878
R4021 VDD.n2824 VDD.n123 2.64878
R4022 VDD.n721 VDD.n714 2.64878
R4023 VDD.n2716 VDD.n734 2.64878
R4024 VDD.n2614 VDD.n813 2.64878
R4025 VDD.n2588 VDD.n848 2.64878
R4026 VDD.n911 VDD.n910 2.64878
R4027 VDD.n2524 VDD.n937 2.64878
R4028 VDD.n1022 VDD.n1021 2.64878
R4029 VDD.n2104 VDD.n1044 2.64878
R4030 VDD.n2521 VDD.t1 2.63939
R4031 VDD.n2832 VDD.t23 2.61999
R4032 VDD.n663 VDD.n101 2.6136
R4033 VDD.n1946 VDD.n965 2.6136
R4034 VDD.n2087 VDD.n1036 2.5161
R4035 VDD.n1835 VDD.n1754 2.49806
R4036 VDD.n1776 VDD.n1774 2.49806
R4037 VDD.n2671 VDD.n2670 2.49806
R4038 VDD.n2643 VDD.n2642 2.49806
R4039 VDD.n2585 VDD.t3 2.39949
R4040 VDD.n439 VDD.n396 2.24193
R4041 VDD.n861 VDD.n860 2.2074
R4042 VDD.n888 VDD.n886 2.2074
R4043 VDD.n2519 VDD.n943 2.2074
R4044 VDD.n2499 VDD.n2498 2.2074
R4045 VDD.n1855 VDD.n1034 2.2074
R4046 VDD.n2265 VDD.n2263 2.18587
R4047 VDD.n2367 VDD.n2277 2.18587
R4048 VDD.n366 VDD.n311 2.18587
R4049 VDD.n346 VDD.n343 2.18587
R4050 VDD.n389 VDD.n286 2.1834
R4051 VDD.n1854 VDD.n1741 1.87367
R4052 VDD.n1839 VDD.n1838 1.87367
R4053 VDD.n1809 VDD.n1778 1.87367
R4054 VDD.n1794 VDD.n1787 1.87367
R4055 VDD.n2689 VDD.n2688 1.87367
R4056 VDD.n2674 VDD.n785 1.87367
R4057 VDD.n2639 VDD.n2638 1.87367
R4058 VDD.n2623 VDD.n804 1.87367
R4059 VDD.n280 VDD.n278 1.76602
R4060 VDD.n520 VDD.n235 1.76602
R4061 VDD.n540 VDD.n222 1.76602
R4062 VDD.n676 VDD.n675 1.76602
R4063 VDD.n684 VDD.n683 1.76602
R4064 VDD.n1217 VDD.n1216 1.76602
R4065 VDD.n1225 VDD.n1224 1.76602
R4066 VDD.n2319 VDD.n2314 1.76602
R4067 VDD.n2323 VDD.n2310 1.76602
R4068 VDD.n2456 VDD.n1035 1.76602
R4069 VDD.n1373 VDD.n1352 1.76602
R4070 VDD.n1383 VDD.n1374 1.76602
R4071 VDD.n1705 VDD.n1704 1.76602
R4072 VDD.n1717 VDD.n1716 1.76602
R4073 VDD.n1857 VDD.n1856 1.76602
R4074 VDD.n300 VDD.n274 1.76602
R4075 VDD.n526 VDD.n228 1.76602
R4076 VDD.n2877 VDD.n64 1.76602
R4077 VDD.n2838 VDD.n110 1.76602
R4078 VDD.n2828 VDD.n2827 1.76602
R4079 VDD.n2730 VDD.n722 1.76602
R4080 VDD.n2720 VDD.n2719 1.76602
R4081 VDD.n827 VDD.n826 1.76602
R4082 VDD.n2592 VDD.n2591 1.76602
R4083 VDD.n2545 VDD.n2544 1.76602
R4084 VDD.n2525 VDD.n934 1.76602
R4085 VDD.n2469 VDD.n1018 1.76602
R4086 VDD.n2105 VDD.n2103 1.76602
R4087 VDD.n2604 VDD.t19 1.67979
R4088 VDD.n2382 VDD.n2267 1.56148
R4089 VDD.n2368 VDD.n2275 1.56148
R4090 VDD.n363 VDD.n362 1.56148
R4091 VDD.n347 VDD.n316 1.56148
R4092 VDD.n2685 VDD.n766 1.43989
R4093 VDD.t17 VDD.n917 1.43989
R4094 VDD.n2502 VDD.t0 1.43989
R4095 VDD.n1746 VDD.n1028 1.43989
R4096 VDD.n2582 VDD.n857 1.32464
R4097 VDD.n2577 VDD.n866 1.32464
R4098 VDD.n2518 VDD.n944 1.32464
R4099 VDD.n975 VDD.n974 1.32464
R4100 VDD.n1851 VDD.n1850 1.24928
R4101 VDD.n1753 VDD.n1751 1.24928
R4102 VDD.n1808 VDD.n1779 1.24928
R4103 VDD.n1795 VDD.n1785 1.24928
R4104 VDD.n780 VDD.n764 1.24928
R4105 VDD.n2678 VDD.n2675 1.24928
R4106 VDD.n2635 VDD.n797 1.24928
R4107 VDD.n2627 VDD.n2626 1.24928
R4108 VDD.n1570 VDD.t2 1.19999
R4109 VDD.n2381 VDD.n2268 0.937085
R4110 VDD.n2372 VDD.n2371 0.937085
R4111 VDD.n359 VDD.n358 0.937085
R4112 VDD.n351 VDD.n350 0.937085
R4113 VDD.n519 VDD.n236 0.883259
R4114 VDD.n537 VDD.n536 0.883259
R4115 VDD.n677 VDD.n210 0.883259
R4116 VDD.n682 VDD.n681 0.883259
R4117 VDD.n1218 VDD.n1206 0.883259
R4118 VDD.n1223 VDD.n1222 0.883259
R4119 VDD.n2344 VDD.n2343 0.883259
R4120 VDD.n2407 VDD.n2247 0.883259
R4121 VDD.n2460 VDD.n2459 0.883259
R4122 VDD.n1394 VDD.n1393 0.883259
R4123 VDD.n1387 VDD.n1386 0.883259
R4124 VDD.n1706 VDD.n1124 0.883259
R4125 VDD.n1713 VDD.n1712 0.883259
R4126 VDD.n530 VDD.n529 0.883259
R4127 VDD.n2878 VDD.n63 0.883259
R4128 VDD.n2837 VDD.n111 0.883259
R4129 VDD.n122 VDD.n115 0.883259
R4130 VDD.n2729 VDD.n723 0.883259
R4131 VDD.n733 VDD.n726 0.883259
R4132 VDD.n2608 VDD.n2607 0.883259
R4133 VDD.n847 VDD.n846 0.883259
R4134 VDD.n932 VDD.n912 0.883259
R4135 VDD.n2529 VDD.n2528 0.883259
R4136 VDD.n2468 VDD.n1019 0.883259
R4137 VDD.n2101 VDD.n1026 0.883259
R4138 VDD.n2713 VDD.t12 0.873662
R4139 VDD.n1846 VDD.n1743 0.62489
R4140 VDD.n1844 VDD.n1749 0.62489
R4141 VDD.n1805 VDD.n1804 0.62489
R4142 VDD.n1799 VDD.n1798 0.62489
R4143 VDD.n2683 VDD.n781 0.62489
R4144 VDD.n2679 VDD.n782 0.62489
R4145 VDD.n2634 VDD.n798 0.62489
R4146 VDD.n2630 VDD.n803 0.62489
R4147 VDD.n2581 VDD.n858 0.441879
R4148 VDD.n2578 VDD.n865 0.441879
R4149 VDD.n2515 VDD.n2514 0.441879
R4150 VDD.n973 VDD.n951 0.441879
R4151 VDD.n2299 VDD.n2244 0.439908
R4152 VDD.n2152 VDD.n2108 0.4005
R4153 VDD.n2435 VDD.n2434 0.4005
R4154 VDD.n2548 VDD.n908 0.393
R4155 VDD.n2611 VDD.n824 0.393
R4156 VDD.n2705 VDD.n748 0.393
R4157 VDD.n2802 VDD.n2801 0.393
R4158 VDD.n2925 VDD.n2881 0.393
R4159 VDD.n2974 VDD.n13 0.393
R4160 VDD.n1552 VDD.n1551 0.388993
R4161 VDD.n2378 VDD.n2377 0.312695
R4162 VDD.n2274 VDD.n2271 0.312695
R4163 VDD.n355 VDD.n314 0.312695
R4164 VDD.n354 VDD.n315 0.312695
R4165 VDD.n1889 VDD.n1888 0.308
R4166 VDD.n1685 VDD.n1683 0.308
R4167 VDD.n1398 VDD.n1397 0.308
R4168 VDD.n1250 VDD.n1249 0.308
R4169 VDD.n1564 VDD.n1134 0.301493
R4170 VDD.n2418 VDD.n2417 0.3005
R4171 VDD.n2750 VDD.n2749 0.258
R4172 VDD.n670 VDD.n669 0.258
R4173 VDD.n516 VDD.n515 0.258
R4174 VDD.n439 VDD.n438 0.258
R4175 VDD.t16 VDD.n997 0.240399
R4176 VDD.n2947 VDD.n30 0.2355
R4177 VDD.n174 VDD.n30 0.2355
R4178 VDD.n2948 VDD.n2947 0.2308
R4179 VDD.n1328 VDD.n174 0.2308
R4180 VDD.n2342 VDD.n2341 0.155672
R4181 VDD.n2341 VDD.n2295 0.155672
R4182 VDD.n2315 VDD.n2295 0.155672
R4183 VDD.n2320 VDD.n2315 0.155672
R4184 VDD.n2308 VDD.n2307 0.155672
R4185 VDD.n2333 VDD.n2308 0.155672
R4186 VDD.n2333 VDD.n2332 0.155672
R4187 VDD.n2332 VDD.n2309 0.155672
R4188 VDD.n1365 VDD.n1364 0.155672
R4189 VDD.n1366 VDD.n1365 0.155672
R4190 VDD.n1366 VDD.n837 0.155672
R4191 VDD.n2600 VDD.n837 0.155672
R4192 VDD.n2600 VDD.n2599 0.155672
R4193 VDD.n2599 VDD.n838 0.155672
R4194 VDD.n862 VDD.n838 0.155672
R4195 VDD.n863 VDD.n862 0.155672
R4196 VDD.n2580 VDD.n863 0.155672
R4197 VDD.n2580 VDD.n2579 0.155672
R4198 VDD.n2579 VDD.n864 0.155672
R4199 VDD.n889 VDD.n864 0.155672
R4200 VDD.n890 VDD.n889 0.155672
R4201 VDD.n2560 VDD.n890 0.155672
R4202 VDD.n2560 VDD.n2559 0.155672
R4203 VDD.n2559 VDD.n891 0.155672
R4204 VDD.n1695 VDD.n891 0.155672
R4205 VDD.n1696 VDD.n1695 0.155672
R4206 VDD.n1696 VDD.n922 0.155672
R4207 VDD.n2537 VDD.n922 0.155672
R4208 VDD.n2537 VDD.n2536 0.155672
R4209 VDD.n2536 VDD.n923 0.155672
R4210 VDD.n948 VDD.n923 0.155672
R4211 VDD.n949 VDD.n948 0.155672
R4212 VDD.n2517 VDD.n949 0.155672
R4213 VDD.n2517 VDD.n2516 0.155672
R4214 VDD.n2516 VDD.n950 0.155672
R4215 VDD.n977 VDD.n950 0.155672
R4216 VDD.n2497 VDD.n977 0.155672
R4217 VDD.n2497 VDD.n2496 0.155672
R4218 VDD.n2496 VDD.n978 0.155672
R4219 VDD.n1007 VDD.n978 0.155672
R4220 VDD.n1008 VDD.n1007 0.155672
R4221 VDD.n2477 VDD.n1008 0.155672
R4222 VDD.n2477 VDD.n2476 0.155672
R4223 VDD.n2476 VDD.n1009 0.155672
R4224 VDD.n1395 VDD.n1351 0.155672
R4225 VDD.n1385 VDD.n1351 0.155672
R4226 VDD.n1385 VDD.n1384 0.155672
R4227 VDD.n1384 VDD.n1375 0.155672
R4228 VDD.n1375 VDD.n1135 0.155672
R4229 VDD.n1566 VDD.n1131 0.155672
R4230 VDD.n1575 VDD.n1131 0.155672
R4231 VDD.n1576 VDD.n1575 0.155672
R4232 VDD.n1576 VDD.n1128 0.155672
R4233 VDD.n1583 VDD.n1128 0.155672
R4234 VDD.n1708 VDD.n1707 0.155672
R4235 VDD.n1708 VDD.n1123 0.155672
R4236 VDD.n1718 VDD.n1123 0.155672
R4237 VDD.n1719 VDD.n1718 0.155672
R4238 VDD.n1719 VDD.n1120 0.155672
R4239 VDD.n1881 VDD.n1731 0.155672
R4240 VDD.n1734 VDD.n1731 0.155672
R4241 VDD.n1872 VDD.n1734 0.155672
R4242 VDD.n1872 VDD.n1871 0.155672
R4243 VDD.n1871 VDD.n1735 0.155672
R4244 VDD.n2457 VDD.n1037 0.155672
R4245 VDD.n2231 VDD.n1037 0.155672
R4246 VDD.n2235 VDD.n2231 0.155672
R4247 VDD.n2236 VDD.n2235 0.155672
R4248 VDD.n2236 VDD.n2229 0.155672
R4249 VDD.n453 VDD.n452 0.155672
R4250 VDD.n453 VDD.n259 0.155672
R4251 VDD.n473 VDD.n259 0.155672
R4252 VDD.n474 VDD.n473 0.155672
R4253 VDD.n475 VDD.n474 0.155672
R4254 VDD.n475 VDD.n245 0.155672
R4255 VDD.n497 VDD.n245 0.155672
R4256 VDD.n498 VDD.n497 0.155672
R4257 VDD.n499 VDD.n498 0.155672
R4258 VDD.n499 VDD.n229 0.155672
R4259 VDD.n527 VDD.n229 0.155672
R4260 VDD.n2879 VDD.n62 0.155672
R4261 VDD.n76 VDD.n62 0.155672
R4262 VDD.n2869 VDD.n76 0.155672
R4263 VDD.n2869 VDD.n2868 0.155672
R4264 VDD.n2868 VDD.n77 0.155672
R4265 VDD.n88 VDD.n77 0.155672
R4266 VDD.n2858 VDD.n88 0.155672
R4267 VDD.n2858 VDD.n2857 0.155672
R4268 VDD.n2857 VDD.n89 0.155672
R4269 VDD.n100 VDD.n89 0.155672
R4270 VDD.n2847 VDD.n100 0.155672
R4271 VDD.n2836 VDD.n113 0.155672
R4272 VDD.n2836 VDD.n2835 0.155672
R4273 VDD.n2835 VDD.n114 0.155672
R4274 VDD.n2826 VDD.n114 0.155672
R4275 VDD.n2826 VDD.n2825 0.155672
R4276 VDD.n2825 VDD.n124 0.155672
R4277 VDD.n135 VDD.n124 0.155672
R4278 VDD.n2815 VDD.n135 0.155672
R4279 VDD.n2815 VDD.n2814 0.155672
R4280 VDD.n2814 VDD.n136 0.155672
R4281 VDD.n147 VDD.n136 0.155672
R4282 VDD.n2739 VDD.n2738 0.155672
R4283 VDD.n2738 VDD.n713 0.155672
R4284 VDD.n724 VDD.n713 0.155672
R4285 VDD.n2728 VDD.n724 0.155672
R4286 VDD.n2728 VDD.n2727 0.155672
R4287 VDD.n2727 VDD.n725 0.155672
R4288 VDD.n2718 VDD.n725 0.155672
R4289 VDD.n2718 VDD.n2717 0.155672
R4290 VDD.n2717 VDD.n735 0.155672
R4291 VDD.n746 VDD.n735 0.155672
R4292 VDD.n2703 VDD.n2702 0.155672
R4293 VDD.n2702 VDD.n750 0.155672
R4294 VDD.n814 VDD.n750 0.155672
R4295 VDD.n821 VDD.n814 0.155672
R4296 VDD.n822 VDD.n821 0.155672
R4297 VDD.n2609 VDD.n825 0.155672
R4298 VDD.n849 VDD.n825 0.155672
R4299 VDD.n2590 VDD.n849 0.155672
R4300 VDD.n2590 VDD.n2589 0.155672
R4301 VDD.n2589 VDD.n850 0.155672
R4302 VDD.n2570 VDD.n875 0.155672
R4303 VDD.n2570 VDD.n2569 0.155672
R4304 VDD.n2569 VDD.n876 0.155672
R4305 VDD.n905 VDD.n876 0.155672
R4306 VDD.n906 VDD.n905 0.155672
R4307 VDD.n935 VDD.n909 0.155672
R4308 VDD.n2527 VDD.n935 0.155672
R4309 VDD.n2527 VDD.n2526 0.155672
R4310 VDD.n2526 VDD.n936 0.155672
R4311 VDD.n963 VDD.n936 0.155672
R4312 VDD.n2506 VDD.n966 0.155672
R4313 VDD.n992 VDD.n966 0.155672
R4314 VDD.n993 VDD.n992 0.155672
R4315 VDD.n2487 VDD.n993 0.155672
R4316 VDD.n2487 VDD.n2486 0.155672
R4317 VDD.n2467 VDD.n1024 0.155672
R4318 VDD.n2106 VDD.n1046 0.155672
R4319 VDD.n2448 VDD.n1046 0.155672
R4320 VDD.n2448 VDD.n2447 0.155672
R4321 VDD.n2447 VDD.n1047 0.155672
R4322 VDD.n1196 VDD.n761 0.155672
R4323 VDD.n2692 VDD.n761 0.155672
R4324 VDD.n1212 VDD.n1209 0.155672
R4325 VDD.n1213 VDD.n1212 0.155672
R4326 VDD.n1213 VDD.n1207 0.155672
R4327 VDD.n1219 VDD.n1207 0.155672
R4328 VDD.n1220 VDD.n1219 0.155672
R4329 VDD.n1220 VDD.n1204 0.155672
R4330 VDD.n1226 VDD.n1204 0.155672
R4331 VDD.n1227 VDD.n1226 0.155672
R4332 VDD.n1227 VDD.n1201 0.155672
R4333 VDD.n1233 VDD.n1201 0.155672
R4334 VDD.n678 VDD.n211 0.155672
R4335 VDD.n679 VDD.n678 0.155672
R4336 VDD.n679 VDD.n208 0.155672
R4337 VDD.n685 VDD.n208 0.155672
R4338 VDD.n686 VDD.n685 0.155672
R4339 VDD.n686 VDD.n205 0.155672
R4340 VDD.n692 VDD.n205 0.155672
R4341 VDD.n693 VDD.n692 0.155672
R4342 VDD.n693 VDD.n203 0.155672
R4343 VDD.n700 VDD.n203 0.155672
R4344 VDD.n701 VDD.n700 0.155672
R4345 VDD.n539 VDD.n538 0.155672
R4346 VDD.n539 VDD.n221 0.155672
R4347 VDD.n545 VDD.n221 0.155672
R4348 VDD.n546 VDD.n545 0.155672
R4349 VDD.n546 VDD.n218 0.155672
R4350 VDD.n552 VDD.n218 0.155672
R4351 VDD.n553 VDD.n552 0.155672
R4352 VDD.n553 VDD.n216 0.155672
R4353 VDD.n560 VDD.n216 0.155672
R4354 VDD.n561 VDD.n560 0.155672
R4355 VDD.n561 VDD.n214 0.155672
R4356 VDD.n463 VDD.n462 0.155672
R4357 VDD.n464 VDD.n463 0.155672
R4358 VDD.n464 VDD.n252 0.155672
R4359 VDD.n484 VDD.n252 0.155672
R4360 VDD.n485 VDD.n484 0.155672
R4361 VDD.n488 VDD.n485 0.155672
R4362 VDD.n488 VDD.n487 0.155672
R4363 VDD.n487 VDD.n237 0.155672
R4364 VDD.n509 VDD.n237 0.155672
R4365 VDD.n510 VDD.n509 0.155672
R4366 VDD.n2546 VDD.n909 0.15515
R4367 VDD.n1687 VDD.n1583 0.154627
R4368 VDD.n1247 VDD.n1196 0.154627
R4369 VDD.n2349 VDD.n2293 0.152939
R4370 VDD.n1707 VDD.n1125 0.152538
R4371 VDD.n1058 VDD.n1047 0.152538
R4372 VDD.n1234 VDD.n1233 0.152538
R4373 VDD.n2550 VDD.n906 0.152015
R4374 VDD.n2707 VDD.n746 0.151493
R4375 VDD.n2253 VDD.n2252 0.14989
R4376 VDD.n385 VDD.n305 0.14989
R4377 VDD.n1145 VDD.n850 0.147835
R4378 VDD.n1882 VDD.n1881 0.147313
R4379 VDD.n2739 VDD.n149 0.147313
R4380 VDD.n2613 VDD.n822 0.147313
R4381 VDD.n1562 VDD.n1135 0.14679
R4382 VDD.n1355 VDD.n762 0.14679
R4383 VDD.n2467 VDD.n2466 0.14679
R4384 VDD.n528 VDD.n527 0.145746
R4385 VDD.n2507 VDD.n2506 0.145223
R4386 VDD.n113 VDD.n112 0.144701
R4387 VDD.n1024 VDD.n1023 0.144701
R4388 VDD.n1863 VDD.n1735 0.144178
R4389 VDD.n1862 VDD.n1737 0.144178
R4390 VDD.n2458 VDD.n2457 0.143656
R4391 VDD.n2847 VDD.n2846 0.143656
R4392 VDD.n2486 VDD.n994 0.143656
R4393 VDD.n964 VDD.n963 0.143133
R4394 VDD.n1476 VDD.n1099 0.1415
R4395 VDD.n1968 VDD.n1099 0.1415
R4396 VDD.n2880 VDD.n2879 0.138823
R4397 VDD.n462 VDD.n265 0.137079
R4398 VDD.n1476 VDD.n1475 0.1368
R4399 VDD.n2066 VDD.n1968 0.1368
R4400 VDD.n1863 VDD.n1862 0.136274
R4401 VDD.n1023 VDD.n994 0.136274
R4402 VDD.n2200 VDD.n2174 0.1321
R4403 VDD.n1475 VDD.n1328 0.13116
R4404 VDD.n1396 VDD.n1395 0.130202
R4405 VDD.n1566 VDD.n1565 0.130202
R4406 VDD.n2107 VDD.n2106 0.130202
R4407 VDD.n1887 VDD.n1120 0.125892
R4408 VDD.n148 VDD.n147 0.125892
R4409 VDD.n2610 VDD.n2609 0.125892
R4410 VDD.n2416 VDD.n2229 0.121581
R4411 VDD.n1553 VDD.n875 0.121581
R4412 VDD.n1853 VDD.n1740 0.119402
R4413 VDD.n1790 VDD.n1786 0.119402
R4414 VDD.n2691 VDD.n2690 0.119402
R4415 VDD.n2624 VDD.n805 0.119402
R4416 VDD.n61 VDD.n60 0.117924
R4417 VDD.n2293 VDD.n2292 0.117663
R4418 VDD.n1740 VDD.n1737 0.112569
R4419 VDD.n1364 VDD.n805 0.110414
R4420 VDD.n1790 VDD.n1009 0.110414
R4421 VDD.n1563 VDD.n1133 0.110348
R4422 VDD.n1350 VDD.n1349 0.110348
R4423 VDD.n2100 VDD.n1025 0.110348
R4424 VDD.n1853 VDD.n1852 0.110256
R4425 VDD.n1852 VDD.n1742 0.110256
R4426 VDD.n1748 VDD.n1742 0.110256
R4427 VDD.n1755 VDD.n1748 0.110256
R4428 VDD.n1756 VDD.n1755 0.110256
R4429 VDD.n1837 VDD.n1756 0.110256
R4430 VDD.n1837 VDD.n1836 0.110256
R4431 VDD.n1836 VDD.n1757 0.110256
R4432 VDD.n1764 VDD.n1757 0.110256
R4433 VDD.n1827 VDD.n1764 0.110256
R4434 VDD.n1827 VDD.n1826 0.110256
R4435 VDD.n1826 VDD.n1765 0.110256
R4436 VDD.n1772 VDD.n1765 0.110256
R4437 VDD.n1817 VDD.n1772 0.110256
R4438 VDD.n1817 VDD.n1816 0.110256
R4439 VDD.n1816 VDD.n1773 0.110256
R4440 VDD.n1780 VDD.n1773 0.110256
R4441 VDD.n1807 VDD.n1780 0.110256
R4442 VDD.n1807 VDD.n1806 0.110256
R4443 VDD.n1806 VDD.n1781 0.110256
R4444 VDD.n1797 VDD.n1781 0.110256
R4445 VDD.n1797 VDD.n1796 0.110256
R4446 VDD.n1796 VDD.n1786 0.110256
R4447 VDD.n2400 VDD.n2253 0.110256
R4448 VDD.n2400 VDD.n2399 0.110256
R4449 VDD.n2399 VDD.n2254 0.110256
R4450 VDD.n2261 VDD.n2254 0.110256
R4451 VDD.n2390 VDD.n2261 0.110256
R4452 VDD.n2390 VDD.n2389 0.110256
R4453 VDD.n2389 VDD.n2262 0.110256
R4454 VDD.n2269 VDD.n2262 0.110256
R4455 VDD.n2380 VDD.n2269 0.110256
R4456 VDD.n2380 VDD.n2379 0.110256
R4457 VDD.n2379 VDD.n2270 0.110256
R4458 VDD.n2370 VDD.n2270 0.110256
R4459 VDD.n2370 VDD.n2369 0.110256
R4460 VDD.n2369 VDD.n2276 0.110256
R4461 VDD.n2283 VDD.n2276 0.110256
R4462 VDD.n2360 VDD.n2283 0.110256
R4463 VDD.n2360 VDD.n2359 0.110256
R4464 VDD.n2359 VDD.n2284 0.110256
R4465 VDD.n2291 VDD.n2284 0.110256
R4466 VDD.n2350 VDD.n2291 0.110256
R4467 VDD.n2350 VDD.n2349 0.110256
R4468 VDD.n2690 VDD.n763 0.110256
R4469 VDD.n783 VDD.n763 0.110256
R4470 VDD.n2681 VDD.n783 0.110256
R4471 VDD.n2681 VDD.n2680 0.110256
R4472 VDD.n2680 VDD.n784 0.110256
R4473 VDD.n787 VDD.n784 0.110256
R4474 VDD.n2669 VDD.n787 0.110256
R4475 VDD.n2669 VDD.n2668 0.110256
R4476 VDD.n2668 VDD.n788 0.110256
R4477 VDD.n791 VDD.n788 0.110256
R4478 VDD.n2657 VDD.n791 0.110256
R4479 VDD.n2657 VDD.n2656 0.110256
R4480 VDD.n2656 VDD.n792 0.110256
R4481 VDD.n795 VDD.n792 0.110256
R4482 VDD.n2645 VDD.n795 0.110256
R4483 VDD.n2645 VDD.n2644 0.110256
R4484 VDD.n2644 VDD.n796 0.110256
R4485 VDD.n799 VDD.n796 0.110256
R4486 VDD.n2633 VDD.n799 0.110256
R4487 VDD.n2633 VDD.n2632 0.110256
R4488 VDD.n2632 VDD.n800 0.110256
R4489 VDD.n2625 VDD.n800 0.110256
R4490 VDD.n2625 VDD.n2624 0.110256
R4491 VDD.n385 VDD.n384 0.110256
R4492 VDD.n384 VDD.n306 0.110256
R4493 VDD.n377 VDD.n306 0.110256
R4494 VDD.n377 VDD.n376 0.110256
R4495 VDD.n376 VDD.n309 0.110256
R4496 VDD.n312 VDD.n309 0.110256
R4497 VDD.n365 VDD.n312 0.110256
R4498 VDD.n365 VDD.n364 0.110256
R4499 VDD.n364 VDD.n313 0.110256
R4500 VDD.n317 VDD.n313 0.110256
R4501 VDD.n318 VDD.n317 0.110256
R4502 VDD.n349 VDD.n318 0.110256
R4503 VDD.n349 VDD.n348 0.110256
R4504 VDD.n348 VDD.n319 0.110256
R4505 VDD.n322 VDD.n319 0.110256
R4506 VDD.n337 VDD.n322 0.110256
R4507 VDD.n337 VDD.n336 0.110256
R4508 VDD.n336 VDD.n323 0.110256
R4509 VDD.n324 VDD.n323 0.110256
R4510 VDD.n393 VDD.n282 0.110256
R4511 VDD.n2691 VDD.n762 0.108259
R4512 VDD.n1886 VDD.n1119 0.106561
R4513 VDD.n2804 VDD.n2803 0.106561
R4514 VDD.n2612 VDD.n823 0.106561
R4515 VDD.n2045 VDD.n2000 0.105763
R4516 VDD.n2017 VDD.n2016 0.105763
R4517 VDD.n2034 VDD.n2007 0.105763
R4518 VDD.n2034 VDD.n2008 0.105763
R4519 VDD.n2023 VDD.n1969 0.105763
R4520 VDD.n1970 VDD.n1969 0.105763
R4521 VDD.n2057 VDD.n2056 0.105763
R4522 VDD.n2056 VDD.n1980 0.105763
R4523 VDD.n1947 VDD.n1902 0.105763
R4524 VDD.n1925 VDD.n1921 0.105763
R4525 VDD.n1921 VDD.n1920 0.105763
R4526 VDD.n1890 VDD.n1115 0.105763
R4527 VDD.n1678 VDD.n1677 0.105763
R4528 VDD.n1654 VDD.n1653 0.105763
R4529 VDD.n1653 VDD.n1652 0.105763
R4530 VDD.n1682 VDD.n1586 0.105763
R4531 VDD.n1550 VDD.n1549 0.105763
R4532 VDD.n1525 VDD.n1524 0.105763
R4533 VDD.n1524 VDD.n1523 0.105763
R4534 VDD.n1503 VDD.n1500 0.105763
R4535 VDD.n2153 VDD.n2099 0.105763
R4536 VDD.n2131 VDD.n2127 0.105763
R4537 VDD.n2127 VDD.n2126 0.105763
R4538 VDD.n2088 VDD.n2083 0.105763
R4539 VDD.n2433 VDD.n2432 0.105763
R4540 VDD.n2198 VDD.n2194 0.105763
R4541 VDD.n2198 VDD.n2197 0.105763
R4542 VDD.n2419 VDD.n1081 0.105763
R4543 VDD.n1454 VDD.n1453 0.105763
R4544 VDD.n1427 VDD.n1425 0.105763
R4545 VDD.n1425 VDD.n1424 0.105763
R4546 VDD.n1399 VDD.n1345 0.105763
R4547 VDD.n1307 VDD.n1306 0.105763
R4548 VDD.n1280 VDD.n1278 0.105763
R4549 VDD.n1278 VDD.n1277 0.105763
R4550 VDD.n1251 VDD.n1190 0.105763
R4551 VDD.n2800 VDD.n2799 0.105763
R4552 VDD.n2775 VDD.n2774 0.105763
R4553 VDD.n2753 VDD.n198 0.105763
R4554 VDD.n664 VDD.n581 0.105763
R4555 VDD.n638 VDD.n600 0.105763
R4556 VDD.n668 VDD.n571 0.105763
R4557 VDD.n2926 VDD.n59 0.105763
R4558 VDD.n2900 VDD.n2899 0.105763
R4559 VDD.n48 VDD.n46 0.105763
R4560 VDD.n2975 VDD.n12 0.105763
R4561 VDD.n405 VDD.n1 0.105763
R4562 VDD.n407 VDD.n405 0.105763
R4563 VDD.n437 VDD.n436 0.105763
R4564 VDD.n2415 VDD.n2228 0.102773
R4565 VDD.n1554 VDD.n1146 0.102773
R4566 VDD.n2024 VDD.n2020 0.102474
R4567 VDD.n1989 VDD.n1985 0.102474
R4568 VDD.n2040 VDD.n2004 0.0958947
R4569 VDD.n2063 VDD.n1972 0.0958947
R4570 VDD.n1941 VDD.n1906 0.0926053
R4571 VDD.n1926 VDD.n1917 0.0926053
R4572 VDD.n1965 VDD.n1103 0.0926053
R4573 VDD.n1953 VDD.n1952 0.0926053
R4574 VDD.n1601 VDD.n1596 0.0926053
R4575 VDD.n1613 VDD.n1610 0.0926053
R4576 VDD.n1648 VDD.n1616 0.0926053
R4577 VDD.n1636 VDD.n1635 0.0926053
R4578 VDD.n1153 VDD.n1149 0.0926053
R4579 VDD.n1480 VDD.n1478 0.0926053
R4580 VDD.n1519 VDD.n1483 0.0926053
R4581 VDD.n1507 VDD.n1506 0.0926053
R4582 VDD.n2147 VDD.n2112 0.0926053
R4583 VDD.n2132 VDD.n2123 0.0926053
R4584 VDD.n2171 VDD.n2070 0.0926053
R4585 VDD.n2159 VDD.n2158 0.0926053
R4586 VDD.n1068 VDD.n1064 0.0926053
R4587 VDD.n2193 VDD.n2176 0.0926053
R4588 VDD.n2203 VDD.n1090 0.0926053
R4589 VDD.n2223 VDD.n2222 0.0926053
R4590 VDD.n1415 VDD.n1410 0.0926053
R4591 VDD.n1431 VDD.n1430 0.0926053
R4592 VDD.n1472 VDD.n1332 0.0926053
R4593 VDD.n1460 VDD.n1459 0.0926053
R4594 VDD.n1267 VDD.n1262 0.0926053
R4595 VDD.n1284 VDD.n1283 0.0926053
R4596 VDD.n1313 VDD.n1312 0.0926053
R4597 VDD.n156 VDD.n152 0.0926053
R4598 VDD.n178 VDD.n176 0.0926053
R4599 VDD.n2769 VDD.n181 0.0926053
R4600 VDD.n2757 VDD.n2756 0.0926053
R4601 VDD.n658 VDD.n585 0.0926053
R4602 VDD.n643 VDD.n596 0.0926053
R4603 VDD.n637 VDD.n634 0.0926053
R4604 VDD.n614 VDD.n613 0.0926053
R4605 VDD.n2920 VDD.n2885 0.0926053
R4606 VDD.n2905 VDD.n2896 0.0926053
R4607 VDD.n2944 VDD.n33 0.0926053
R4608 VDD.n2932 VDD.n2931 0.0926053
R4609 VDD.n2969 VDD.n17 0.0926053
R4610 VDD.n411 VDD.n409 0.0926053
R4611 VDD.n425 VDD.n398 0.0926053
R4612 VDD.n452 VDD.n451 0.0919316
R4613 VDD.n2704 VDD.n2703 0.0914091
R4614 VDD.n2774 VDD 0.0909605
R4615 VDD VDD.n2900 0.0909605
R4616 VDD.n2025 VDD.n2015 0.0893158
R4617 VDD.n2051 VDD.n2050 0.0893158
R4618 VDD.n2547 VDD.n2546 0.0876212
R4619 VDD.n2436 VDD.n1060 0.0876212
R4620 VDD.n395 VDD.n394 0.0875098
R4621 VDD VDD.n282 0.0843415
R4622 VDD.n1687 VDD.n1686 0.0838333
R4623 VDD.n1248 VDD.n1247 0.0838333
R4624 VDD.n2039 VDD.n2005 0.0827368
R4625 VDD.n2062 VDD.n1973 0.0827368
R4626 VDD.n1935 VDD.n1909 0.0805
R4627 VDD.n1935 VDD.n1910 0.0805
R4628 VDD.n1924 VDD.n1100 0.0805
R4629 VDD.n1101 VDD.n1100 0.0805
R4630 VDD.n1959 VDD.n1958 0.0805
R4631 VDD.n1958 VDD.n1110 0.0805
R4632 VDD.n1671 VDD.n1600 0.0805
R4633 VDD.n1605 VDD.n1600 0.0805
R4634 VDD.n1655 VDD.n1609 0.0805
R4635 VDD.n1651 VDD.n1609 0.0805
R4636 VDD.n1642 VDD.n1641 0.0805
R4637 VDD.n1641 VDD.n1623 0.0805
R4638 VDD.n2141 VDD.n2115 0.0805
R4639 VDD.n2141 VDD.n2116 0.0805
R4640 VDD.n2130 VDD.n2067 0.0805
R4641 VDD.n2068 VDD.n2067 0.0805
R4642 VDD.n2165 VDD.n2164 0.0805
R4643 VDD.n2164 VDD.n2078 0.0805
R4644 VDD.n2426 VDD.n1067 0.0805
R4645 VDD.n2181 VDD.n1067 0.0805
R4646 VDD.n2199 VDD.n2175 0.0805
R4647 VDD.n2199 VDD.n1091 0.0805
R4648 VDD.n2217 VDD.n1086 0.0805
R4649 VDD.n2218 VDD.n2217 0.0805
R4650 VDD.n1447 VDD.n1414 0.0805
R4651 VDD.n1419 VDD.n1414 0.0805
R4652 VDD.n1426 VDD.n1329 0.0805
R4653 VDD.n1330 VDD.n1329 0.0805
R4654 VDD.n1466 VDD.n1465 0.0805
R4655 VDD.n1465 VDD.n1340 0.0805
R4656 VDD.n1300 VDD.n1266 0.0805
R4657 VDD.n1271 VDD.n1266 0.0805
R4658 VDD.n1279 VDD.n1175 0.0805
R4659 VDD.n1176 VDD.n1175 0.0805
R4660 VDD.n1319 VDD.n1318 0.0805
R4661 VDD.n1318 VDD.n1185 0.0805
R4662 VDD.n2793 VDD.n155 0.0805
R4663 VDD.n170 VDD.n155 0.0805
R4664 VDD.n2776 VDD.n175 0.0805
R4665 VDD.n2772 VDD.n175 0.0805
R4666 VDD.n2763 VDD.n2762 0.0805
R4667 VDD.n2762 VDD.n188 0.0805
R4668 VDD.n652 VDD.n588 0.0805
R4669 VDD.n652 VDD.n589 0.0805
R4670 VDD.n641 VDD.n640 0.0805
R4671 VDD.n640 VDD.n639 0.0805
R4672 VDD.n628 VDD.n605 0.0805
R4673 VDD.n621 VDD.n605 0.0805
R4674 VDD.n2914 VDD.n2888 0.0805
R4675 VDD.n2914 VDD.n2889 0.0805
R4676 VDD.n2903 VDD.n29 0.0805
R4677 VDD.n31 VDD.n29 0.0805
R4678 VDD.n2938 VDD.n2937 0.0805
R4679 VDD.n2937 VDD.n41 0.0805
R4680 VDD.n2963 VDD.n20 0.0805
R4681 VDD.n2963 VDD.n21 0.0805
R4682 VDD.n26 VDD.n23 0.0805
R4683 VDD.n406 VDD.n26 0.0805
R4684 VDD.n419 VDD.n401 0.0805
R4685 VDD.n430 VDD.n401 0.0805
R4686 VDD.n2044 VDD.n2001 0.0794474
R4687 VDD.n2041 VDD.n2003 0.0794474
R4688 VDD.n2031 VDD.n2030 0.0794474
R4689 VDD.n2022 VDD.n2021 0.0794474
R4690 VDD.n2065 VDD.n2064 0.0794474
R4691 VDD.n1978 VDD.n1977 0.0794474
R4692 VDD.n2053 VDD.n2052 0.0794474
R4693 VDD.n1988 VDD.n1987 0.0794474
R4694 VDD.n1940 VDD.n1907 0.0794474
R4695 VDD.n1930 VDD.n1929 0.0794474
R4696 VDD.n1964 VDD.n1104 0.0794474
R4697 VDD.n1893 VDD.n1114 0.0794474
R4698 VDD.n1670 VDD.n1602 0.0794474
R4699 VDD.n1661 VDD.n1604 0.0794474
R4700 VDD.n1647 VDD.n1618 0.0794474
R4701 VDD.n1634 VDD.n1632 0.0794474
R4702 VDD.n1542 VDD.n1154 0.0794474
R4703 VDD.n1532 VDD.n1166 0.0794474
R4704 VDD.n1518 VDD.n1485 0.0794474
R4705 VDD.n1499 VDD.n1498 0.0794474
R4706 VDD.n2146 VDD.n2113 0.0794474
R4707 VDD.n2136 VDD.n2135 0.0794474
R4708 VDD.n2170 VDD.n2071 0.0794474
R4709 VDD.n2094 VDD.n2082 0.0794474
R4710 VDD.n2425 VDD.n1069 0.0794474
R4711 VDD.n2190 VDD.n2189 0.0794474
R4712 VDD.n2212 VDD.n2204 0.0794474
R4713 VDD.n2221 VDD.n2219 0.0794474
R4714 VDD.n1446 VDD.n1416 0.0794474
R4715 VDD.n1437 VDD.n1418 0.0794474
R4716 VDD.n1405 VDD.n1344 0.0794474
R4717 VDD.n1299 VDD.n1268 0.0794474
R4718 VDD.n1290 VDD.n1270 0.0794474
R4719 VDD.n1324 VDD.n1178 0.0794474
R4720 VDD.n1257 VDD.n1189 0.0794474
R4721 VDD.n2792 VDD.n157 0.0794474
R4722 VDD.n2782 VDD.n169 0.0794474
R4723 VDD.n2768 VDD.n183 0.0794474
R4724 VDD.n197 VDD.n196 0.0794474
R4725 VDD.n657 VDD.n586 0.0794474
R4726 VDD.n647 VDD.n646 0.0794474
R4727 VDD.n606 VDD.n602 0.0794474
R4728 VDD.n622 VDD.n612 0.0794474
R4729 VDD.n2919 VDD.n2886 0.0794474
R4730 VDD.n2909 VDD.n2908 0.0794474
R4731 VDD.n2943 VDD.n34 0.0794474
R4732 VDD.n50 VDD.n45 0.0794474
R4733 VDD.n2968 VDD.n18 0.0794474
R4734 VDD.n2958 VDD.n2957 0.0794474
R4735 VDD.n415 VDD.n414 0.0794474
R4736 VDD.n429 VDD.n428 0.0794474
R4737 VDD.n1209 VDD.n199 0.0791004
R4738 VDD.n642 VDD 0.0778026
R4739 VDD.n450 VDD.n273 0.0762576
R4740 VDD.n2706 VDD.n747 0.0762576
R4741 VDD.n2252 VDD.n1061 0.0762576
R4742 VDD.n2029 VDD.n2028 0.0761579
R4743 VDD.n1995 VDD.n1984 0.0761579
R4744 VDD.n2507 VDD.n965 0.0759522
R4745 VDD.n1543 VDD.n1152 0.0752664
R4746 VDD.n1167 VDD.n1152 0.0752664
R4747 VDD.n1526 VDD.n1477 0.0752664
R4748 VDD.n1522 VDD.n1477 0.0752664
R4749 VDD.n1513 VDD.n1512 0.0752664
R4750 VDD.n1512 VDD.n1489 0.0752664
R4751 VDD.n511 VDD.n510 0.0747901
R4752 VDD.n2549 VDD.n907 0.0724697
R4753 VDD.n2437 VDD.n1059 0.0724697
R4754 VDD.n1739 VDD.n1036 0.0721643
R4755 VDD.n112 VDD.n101 0.0721643
R4756 VDD.n2174 VDD.n2066 0.06959
R4757 VDD.n2036 VDD.n2035 0.069579
R4758 VDD.n2059 VDD.n2058 0.069579
R4759 VDD.n441 VDD.n440 0.0691274
R4760 VDD.n1684 VDD.n1584 0.0686818
R4761 VDD.n1684 VDD.n1125 0.0686818
R4762 VDD.n1234 VDD.n1194 0.0686818
R4763 VDD.n1195 VDD.n1194 0.0686818
R4764 VDD.n1937 VDD.n1936 0.0662895
R4765 VDD.n1916 VDD.n1913 0.0662895
R4766 VDD.n1961 VDD.n1960 0.0662895
R4767 VDD.n1894 VDD.n1109 0.0662895
R4768 VDD.n1669 VDD.n1666 0.0662895
R4769 VDD.n1662 VDD.n1603 0.0662895
R4770 VDD.n1644 VDD.n1643 0.0662895
R4771 VDD.n1631 VDD.n1622 0.0662895
R4772 VDD.n1541 VDD.n1155 0.0662895
R4773 VDD.n1533 VDD.n1165 0.0662895
R4774 VDD.n1515 VDD.n1514 0.0662895
R4775 VDD.n1497 VDD.n1488 0.0662895
R4776 VDD.n2143 VDD.n2142 0.0662895
R4777 VDD.n2122 VDD.n2119 0.0662895
R4778 VDD.n2167 VDD.n2166 0.0662895
R4779 VDD.n2095 VDD.n2077 0.0662895
R4780 VDD.n2424 VDD.n1070 0.0662895
R4781 VDD.n2180 VDD.n2178 0.0662895
R4782 VDD.n2211 VDD.n2208 0.0662895
R4783 VDD.n1087 VDD.n1085 0.0662895
R4784 VDD.n1445 VDD.n1442 0.0662895
R4785 VDD.n1438 VDD.n1417 0.0662895
R4786 VDD.n1468 VDD.n1467 0.0662895
R4787 VDD.n1406 VDD.n1339 0.0662895
R4788 VDD.n1298 VDD.n1295 0.0662895
R4789 VDD.n1291 VDD.n1269 0.0662895
R4790 VDD.n1321 VDD.n1320 0.0662895
R4791 VDD.n1258 VDD.n1184 0.0662895
R4792 VDD.n2791 VDD.n158 0.0662895
R4793 VDD.n2783 VDD.n168 0.0662895
R4794 VDD.n2765 VDD.n2764 0.0662895
R4795 VDD.n195 VDD.n187 0.0662895
R4796 VDD.n654 VDD.n653 0.0662895
R4797 VDD.n595 VDD.n592 0.0662895
R4798 VDD.n627 VDD.n609 0.0662895
R4799 VDD.n623 VDD.n610 0.0662895
R4800 VDD.n2916 VDD.n2915 0.0662895
R4801 VDD.n2895 VDD.n2892 0.0662895
R4802 VDD.n2940 VDD.n2939 0.0662895
R4803 VDD.n51 VDD.n40 0.0662895
R4804 VDD.n2965 VDD.n2964 0.0662895
R4805 VDD.n2956 VDD.n2953 0.0662895
R4806 VDD.n420 VDD.n403 0.0662895
R4807 VDD.n424 VDD.n402 0.0662895
R4808 VDD.n569 VDD.n214 0.0661694
R4809 VDD.n2550 VDD.n2549 0.0648939
R4810 VDD.n1059 VDD.n1058 0.0648939
R4811 VDD.n1325 VDD 0.0646447
R4812 VDD.n2458 VDD.n1036 0.0645885
R4813 VDD.n2846 VDD.n101 0.0645885
R4814 VDD.n2014 VDD.n2011 0.063
R4815 VDD.n1996 VDD.n1979 0.063
R4816 VDD.n303 VDD.n273 0.0611061
R4817 VDD.n2707 VDD.n2706 0.0611061
R4818 VDD.n965 VDD.n964 0.0608007
R4819 VDD.n1945 VDD.n1903 0.0605
R4820 VDD.n1942 VDD.n1905 0.0605
R4821 VDD.n1932 VDD.n1931 0.0605
R4822 VDD.n1923 VDD.n1922 0.0605
R4823 VDD.n1967 VDD.n1966 0.0605
R4824 VDD.n1108 VDD.n1107 0.0605
R4825 VDD.n1955 VDD.n1954 0.0605
R4826 VDD.n1118 VDD.n1117 0.0605
R4827 VDD.n1676 VDD.n1597 0.0605
R4828 VDD.n1672 VDD.n1598 0.0605
R4829 VDD.n1660 VDD.n1606 0.0605
R4830 VDD.n1656 VDD.n1607 0.0605
R4831 VDD.n1650 VDD.n1649 0.0605
R4832 VDD.n1621 VDD.n1620 0.0605
R4833 VDD.n1638 VDD.n1637 0.0605
R4834 VDD.n1627 VDD.n1585 0.0605
R4835 VDD.n2151 VDD.n2109 0.0605
R4836 VDD.n2148 VDD.n2111 0.0605
R4837 VDD.n2138 VDD.n2137 0.0605
R4838 VDD.n2129 VDD.n2128 0.0605
R4839 VDD.n2173 VDD.n2172 0.0605
R4840 VDD.n2076 VDD.n2075 0.0605
R4841 VDD.n2161 VDD.n2160 0.0605
R4842 VDD.n2086 VDD.n2085 0.0605
R4843 VDD.n2431 VDD.n1062 0.0605
R4844 VDD.n2427 VDD.n1065 0.0605
R4845 VDD.n2188 VDD.n2182 0.0605
R4846 VDD.n2184 VDD.n2183 0.0605
R4847 VDD.n2202 VDD.n2201 0.0605
R4848 VDD.n2214 VDD.n2213 0.0605
R4849 VDD.n2224 VDD.n1084 0.0605
R4850 VDD.n2227 VDD.n1082 0.0605
R4851 VDD.n1452 VDD.n1411 0.0605
R4852 VDD.n1448 VDD.n1412 0.0605
R4853 VDD.n1436 VDD.n1420 0.0605
R4854 VDD.n1432 VDD.n1421 0.0605
R4855 VDD.n1474 VDD.n1473 0.0605
R4856 VDD.n1338 VDD.n1337 0.0605
R4857 VDD.n1462 VDD.n1461 0.0605
R4858 VDD.n1348 VDD.n1347 0.0605
R4859 VDD.n1305 VDD.n1263 0.0605
R4860 VDD.n1301 VDD.n1264 0.0605
R4861 VDD.n1289 VDD.n1272 0.0605
R4862 VDD.n1285 VDD.n1273 0.0605
R4863 VDD.n1327 VDD.n1326 0.0605
R4864 VDD.n1183 VDD.n1182 0.0605
R4865 VDD.n1315 VDD.n1314 0.0605
R4866 VDD.n1193 VDD.n1192 0.0605
R4867 VDD.n2798 VDD.n150 0.0605
R4868 VDD.n2794 VDD.n153 0.0605
R4869 VDD.n2781 VDD.n171 0.0605
R4870 VDD.n2777 VDD.n172 0.0605
R4871 VDD.n2771 VDD.n2770 0.0605
R4872 VDD.n186 VDD.n185 0.0605
R4873 VDD.n2759 VDD.n2758 0.0605
R4874 VDD.n2752 VDD.n2751 0.0605
R4875 VDD.n662 VDD.n582 0.0605
R4876 VDD.n659 VDD.n584 0.0605
R4877 VDD.n649 VDD.n648 0.0605
R4878 VDD.n599 VDD.n597 0.0605
R4879 VDD.n633 VDD.n601 0.0605
R4880 VDD.n629 VDD.n603 0.0605
R4881 VDD.n620 VDD.n615 0.0605
R4882 VDD.n616 VDD.n570 0.0605
R4883 VDD.n2924 VDD.n2882 0.0605
R4884 VDD.n2921 VDD.n2884 0.0605
R4885 VDD.n2911 VDD.n2910 0.0605
R4886 VDD.n2902 VDD.n2901 0.0605
R4887 VDD.n2946 VDD.n2945 0.0605
R4888 VDD.n39 VDD.n38 0.0605
R4889 VDD.n2934 VDD.n2933 0.0605
R4890 VDD.n514 VDD.n513 0.0605
R4891 VDD.n2973 VDD.n14 0.0605
R4892 VDD.n2970 VDD.n16 0.0605
R4893 VDD.n2960 VDD.n2959 0.0605
R4894 VDD.n2951 VDD.n2950 0.0605
R4895 VDD.n410 VDD.n25 0.0605
R4896 VDD.n418 VDD.n416 0.0605
R4897 VDD.n431 VDD.n399 0.0605
R4898 VDD.n435 VDD.n397 0.0605
R4899 VDD.n671 VDD.n211 0.0575487
R4900 VDD.n305 VDD.n303 0.0573182
R4901 VDD.n1548 VDD.n1147 0.0565748
R4902 VDD.n1544 VDD.n1150 0.0565748
R4903 VDD.n1531 VDD.n1168 0.0565748
R4904 VDD.n1527 VDD.n1169 0.0565748
R4905 VDD.n1521 VDD.n1520 0.0565748
R4906 VDD.n1487 VDD.n1486 0.0565748
R4907 VDD.n1509 VDD.n1508 0.0565748
R4908 VDD.n1502 VDD.n1501 0.0565748
R4909 VDD.n2011 VDD.n2006 0.0564211
R4910 VDD.n1979 VDD.n1976 0.0564211
R4911 VDD.n1471 VDD 0.0547763
R4912 VDD.n2748 VDD.n2747 0.0544216
R4913 VDD.n1686 VDD.n1584 0.0535303
R4914 VDD.n1248 VDD.n1195 0.0535303
R4915 VDD.n2042 VDD.n2001 0.0531316
R4916 VDD.n2042 VDD.n2041 0.0531316
R4917 VDD.n2030 VDD.n2010 0.0531316
R4918 VDD.n2021 VDD.n2010 0.0531316
R4919 VDD.n2064 VDD.n1971 0.0531316
R4920 VDD.n1977 VDD.n1971 0.0531316
R4921 VDD.n2052 VDD.n1983 0.0531316
R4922 VDD.n1987 VDD.n1983 0.0531316
R4923 VDD.n1936 VDD.n1908 0.0531316
R4924 VDD.n1913 VDD.n1908 0.0531316
R4925 VDD.n1891 VDD.n1109 0.0531316
R4926 VDD.n1666 VDD.n1665 0.0531316
R4927 VDD.n1665 VDD.n1603 0.0531316
R4928 VDD.n1643 VDD.n1619 0.0531316
R4929 VDD.n1164 VDD.n1155 0.0531316
R4930 VDD.n1165 VDD.n1164 0.0531316
R4931 VDD.n1494 VDD.n1488 0.0531316
R4932 VDD.n2142 VDD.n2114 0.0531316
R4933 VDD.n2119 VDD.n2114 0.0531316
R4934 VDD.n2166 VDD.n2074 0.0531316
R4935 VDD.n2077 VDD.n2074 0.0531316
R4936 VDD.n2179 VDD.n1070 0.0531316
R4937 VDD.n2180 VDD.n2179 0.0531316
R4938 VDD.n2208 VDD.n2207 0.0531316
R4939 VDD.n2207 VDD.n1087 0.0531316
R4940 VDD.n1442 VDD.n1441 0.0531316
R4941 VDD.n1441 VDD.n1417 0.0531316
R4942 VDD.n1467 VDD.n1336 0.0531316
R4943 VDD.n1339 VDD.n1336 0.0531316
R4944 VDD.n1295 VDD.n1294 0.0531316
R4945 VDD.n1294 VDD.n1269 0.0531316
R4946 VDD.n1320 VDD.n1181 0.0531316
R4947 VDD.n1184 VDD.n1181 0.0531316
R4948 VDD.n167 VDD.n158 0.0531316
R4949 VDD.n168 VDD.n167 0.0531316
R4950 VDD.n2764 VDD.n184 0.0531316
R4951 VDD.n187 VDD.n184 0.0531316
R4952 VDD.n653 VDD.n587 0.0531316
R4953 VDD.n592 VDD.n587 0.0531316
R4954 VDD.n627 VDD.n626 0.0531316
R4955 VDD.n626 VDD.n610 0.0531316
R4956 VDD.n2915 VDD.n2887 0.0531316
R4957 VDD.n2892 VDD.n2887 0.0531316
R4958 VDD.n2939 VDD.n37 0.0531316
R4959 VDD.n40 VDD.n37 0.0531316
R4960 VDD.n2964 VDD.n19 0.0531316
R4961 VDD.n2953 VDD.n19 0.0531316
R4962 VDD.n421 VDD.n420 0.0531316
R4963 VDD.n421 VDD.n402 0.0531316
R4964 VDD.n518 VDD.n517 0.0519706
R4965 VDD VDD.n0 0.0514868
R4966 VDD.n417 VDD.n24 0.0499737
R4967 VDD.n417 VDD.n400 0.0499737
R4968 VDD.n432 VDD.n400 0.0499737
R4969 VDD.n433 VDD.n432 0.0499737
R4970 VDD.n1981 VDD.n1095 0.0499737
R4971 VDD.n2055 VDD.n1981 0.0499737
R4972 VDD.n2055 VDD.n2054 0.0499737
R4973 VDD.n2054 VDD.n1982 0.0499737
R4974 VDD.n2043 VDD.n2002 0.0499737
R4975 VDD.n2033 VDD.n2002 0.0499737
R4976 VDD.n2033 VDD.n2032 0.0499737
R4977 VDD.n2032 VDD.n2009 0.0499737
R4978 VDD.n2009 VDD.n1096 0.0499737
R4979 VDD.n1111 VDD.n1097 0.0499737
R4980 VDD.n1957 VDD.n1111 0.0499737
R4981 VDD.n1957 VDD.n1956 0.0499737
R4982 VDD.n1956 VDD.n1112 0.0499737
R4983 VDD.n1944 VDD.n1904 0.0499737
R4984 VDD.n1934 VDD.n1904 0.0499737
R4985 VDD.n1934 VDD.n1933 0.0499737
R4986 VDD.n1933 VDD.n1911 0.0499737
R4987 VDD.n1911 VDD.n1098 0.0499737
R4988 VDD.n1625 VDD.n1624 0.0499737
R4989 VDD.n1640 VDD.n1625 0.0499737
R4990 VDD.n1640 VDD.n1639 0.0499737
R4991 VDD.n1639 VDD.n1626 0.0499737
R4992 VDD.n1674 VDD.n1673 0.0499737
R4993 VDD.n1673 VDD.n1599 0.0499737
R4994 VDD.n1608 VDD.n1599 0.0499737
R4995 VDD.n1658 VDD.n1608 0.0499737
R4996 VDD.n1658 VDD.n1657 0.0499737
R4997 VDD.n1491 VDD.n1490 0.0499737
R4998 VDD.n1511 VDD.n1491 0.0499737
R4999 VDD.n1511 VDD.n1510 0.0499737
R5000 VDD.n1510 VDD.n1492 0.0499737
R5001 VDD.n1546 VDD.n1545 0.0499737
R5002 VDD.n1545 VDD.n1151 0.0499737
R5003 VDD.n1170 VDD.n1151 0.0499737
R5004 VDD.n1529 VDD.n1170 0.0499737
R5005 VDD.n1529 VDD.n1528 0.0499737
R5006 VDD.n2079 VDD.n1093 0.0499737
R5007 VDD.n2163 VDD.n2079 0.0499737
R5008 VDD.n2163 VDD.n2162 0.0499737
R5009 VDD.n2162 VDD.n2080 0.0499737
R5010 VDD.n2150 VDD.n2110 0.0499737
R5011 VDD.n2140 VDD.n2110 0.0499737
R5012 VDD.n2140 VDD.n2139 0.0499737
R5013 VDD.n2139 VDD.n2117 0.0499737
R5014 VDD.n2117 VDD.n1094 0.0499737
R5015 VDD.n2215 VDD.n1088 0.0499737
R5016 VDD.n2216 VDD.n2215 0.0499737
R5017 VDD.n2216 VDD.n1083 0.0499737
R5018 VDD.n2226 VDD.n1083 0.0499737
R5019 VDD.n2429 VDD.n2428 0.0499737
R5020 VDD.n2428 VDD.n1066 0.0499737
R5021 VDD.n2185 VDD.n1066 0.0499737
R5022 VDD.n2186 VDD.n2185 0.0499737
R5023 VDD.n2186 VDD.n1092 0.0499737
R5024 VDD.n1341 VDD.n1171 0.0499737
R5025 VDD.n1464 VDD.n1341 0.0499737
R5026 VDD.n1464 VDD.n1463 0.0499737
R5027 VDD.n1463 VDD.n1342 0.0499737
R5028 VDD.n1450 VDD.n1449 0.0499737
R5029 VDD.n1449 VDD.n1413 0.0499737
R5030 VDD.n1433 VDD.n1413 0.0499737
R5031 VDD.n1434 VDD.n1433 0.0499737
R5032 VDD.n1434 VDD.n1172 0.0499737
R5033 VDD.n1186 VDD.n1173 0.0499737
R5034 VDD.n1317 VDD.n1186 0.0499737
R5035 VDD.n1317 VDD.n1316 0.0499737
R5036 VDD.n1316 VDD.n1187 0.0499737
R5037 VDD.n1303 VDD.n1302 0.0499737
R5038 VDD.n1302 VDD.n1265 0.0499737
R5039 VDD.n1286 VDD.n1265 0.0499737
R5040 VDD.n1287 VDD.n1286 0.0499737
R5041 VDD.n1287 VDD.n1174 0.0499737
R5042 VDD.n190 VDD.n189 0.0499737
R5043 VDD.n2761 VDD.n190 0.0499737
R5044 VDD.n2761 VDD.n2760 0.0499737
R5045 VDD.n2760 VDD.n191 0.0499737
R5046 VDD.n2796 VDD.n2795 0.0499737
R5047 VDD.n2795 VDD.n154 0.0499737
R5048 VDD.n173 VDD.n154 0.0499737
R5049 VDD.n2779 VDD.n173 0.0499737
R5050 VDD.n2779 VDD.n2778 0.0499737
R5051 VDD.n631 VDD.n630 0.0499737
R5052 VDD.n630 VDD.n604 0.0499737
R5053 VDD.n619 VDD.n604 0.0499737
R5054 VDD.n619 VDD.n618 0.0499737
R5055 VDD.n661 VDD.n583 0.0499737
R5056 VDD.n651 VDD.n583 0.0499737
R5057 VDD.n651 VDD.n650 0.0499737
R5058 VDD.n650 VDD.n590 0.0499737
R5059 VDD.n598 VDD.n590 0.0499737
R5060 VDD.n42 VDD.n27 0.0499737
R5061 VDD.n2936 VDD.n42 0.0499737
R5062 VDD.n2936 VDD.n2935 0.0499737
R5063 VDD.n2935 VDD.n43 0.0499737
R5064 VDD.n2923 VDD.n2883 0.0499737
R5065 VDD.n2913 VDD.n2883 0.0499737
R5066 VDD.n2913 VDD.n2912 0.0499737
R5067 VDD.n2912 VDD.n2890 0.0499737
R5068 VDD.n2890 VDD.n28 0.0499737
R5069 VDD.n2972 VDD.n15 0.0499737
R5070 VDD.n2962 VDD.n15 0.0499737
R5071 VDD.n2962 VDD.n2961 0.0499737
R5072 VDD.n2961 VDD.n22 0.0499737
R5073 VDD.n2949 VDD.n22 0.0499737
R5074 VDD.n2035 VDD.n2006 0.0498421
R5075 VDD.n2058 VDD.n1976 0.0498421
R5076 VDD.n2547 VDD.n907 0.0497424
R5077 VDD.n2437 VDD.n2436 0.0497424
R5078 VDD.n441 VDD.n396 0.0495032
R5079 VDD.n538 VDD.n223 0.048928
R5080 VDD.n568 VDD.n213 0.0470686
R5081 VDD.n451 VDD.n450 0.0459545
R5082 VDD.n2704 VDD.n747 0.0459545
R5083 VDD.n701 VDD.n200 0.0446176
R5084 VDD.n201 VDD.n200 0.0446176
R5085 VDD.n2029 VDD.n2014 0.0432632
R5086 VDD.n1996 VDD.n1995 0.0432632
R5087 VDD.n672 VDD.n213 0.0421667
R5088 VDD.n512 VDD.n223 0.0421667
R5089 VDD.n394 VDD.n393 0.0416585
R5090 VDD VDD.n2980 0.0416184
R5091 VDD.n1943 VDD.n1903 0.0405
R5092 VDD.n1943 VDD.n1942 0.0405
R5093 VDD.n1931 VDD.n1912 0.0405
R5094 VDD.n1922 VDD.n1912 0.0405
R5095 VDD.n1966 VDD.n1102 0.0405
R5096 VDD.n1107 VDD.n1102 0.0405
R5097 VDD.n1954 VDD.n1113 0.0405
R5098 VDD.n1117 VDD.n1113 0.0405
R5099 VDD.n1676 VDD.n1675 0.0405
R5100 VDD.n1675 VDD.n1598 0.0405
R5101 VDD.n1660 VDD.n1659 0.0405
R5102 VDD.n1659 VDD.n1607 0.0405
R5103 VDD.n1649 VDD.n1617 0.0405
R5104 VDD.n1620 VDD.n1617 0.0405
R5105 VDD.n1637 VDD.n1628 0.0405
R5106 VDD.n1628 VDD.n1627 0.0405
R5107 VDD.n2149 VDD.n2109 0.0405
R5108 VDD.n2149 VDD.n2148 0.0405
R5109 VDD.n2137 VDD.n2118 0.0405
R5110 VDD.n2128 VDD.n2118 0.0405
R5111 VDD.n2172 VDD.n2069 0.0405
R5112 VDD.n2075 VDD.n2069 0.0405
R5113 VDD.n2160 VDD.n2081 0.0405
R5114 VDD.n2085 VDD.n2081 0.0405
R5115 VDD.n2431 VDD.n2430 0.0405
R5116 VDD.n2430 VDD.n1065 0.0405
R5117 VDD.n2188 VDD.n2187 0.0405
R5118 VDD.n2187 VDD.n2184 0.0405
R5119 VDD.n2202 VDD.n1089 0.0405
R5120 VDD.n2213 VDD.n1089 0.0405
R5121 VDD.n2225 VDD.n2224 0.0405
R5122 VDD.n2225 VDD.n1082 0.0405
R5123 VDD.n1452 VDD.n1451 0.0405
R5124 VDD.n1451 VDD.n1412 0.0405
R5125 VDD.n1436 VDD.n1435 0.0405
R5126 VDD.n1435 VDD.n1432 0.0405
R5127 VDD.n1473 VDD.n1331 0.0405
R5128 VDD.n1337 VDD.n1331 0.0405
R5129 VDD.n1461 VDD.n1343 0.0405
R5130 VDD.n1347 VDD.n1343 0.0405
R5131 VDD.n1305 VDD.n1304 0.0405
R5132 VDD.n1304 VDD.n1264 0.0405
R5133 VDD.n1289 VDD.n1288 0.0405
R5134 VDD.n1288 VDD.n1285 0.0405
R5135 VDD.n1326 VDD.n1177 0.0405
R5136 VDD.n1182 VDD.n1177 0.0405
R5137 VDD.n1314 VDD.n1188 0.0405
R5138 VDD.n1192 VDD.n1188 0.0405
R5139 VDD.n2798 VDD.n2797 0.0405
R5140 VDD.n2797 VDD.n153 0.0405
R5141 VDD.n2781 VDD.n2780 0.0405
R5142 VDD.n2780 VDD.n172 0.0405
R5143 VDD.n2770 VDD.n182 0.0405
R5144 VDD.n185 VDD.n182 0.0405
R5145 VDD.n2758 VDD.n192 0.0405
R5146 VDD.n2752 VDD.n192 0.0405
R5147 VDD.n660 VDD.n582 0.0405
R5148 VDD.n660 VDD.n659 0.0405
R5149 VDD.n648 VDD.n591 0.0405
R5150 VDD.n597 VDD.n591 0.0405
R5151 VDD.n633 VDD.n632 0.0405
R5152 VDD.n632 VDD.n603 0.0405
R5153 VDD.n617 VDD.n615 0.0405
R5154 VDD.n617 VDD.n616 0.0405
R5155 VDD.n2922 VDD.n2882 0.0405
R5156 VDD.n2922 VDD.n2921 0.0405
R5157 VDD.n2910 VDD.n2891 0.0405
R5158 VDD.n2901 VDD.n2891 0.0405
R5159 VDD.n2945 VDD.n32 0.0405
R5160 VDD.n38 VDD.n32 0.0405
R5161 VDD.n2933 VDD.n44 0.0405
R5162 VDD.n513 VDD.n44 0.0405
R5163 VDD.n2971 VDD.n14 0.0405
R5164 VDD.n2971 VDD.n2970 0.0405
R5165 VDD.n2959 VDD.n2952 0.0405
R5166 VDD.n2952 VDD.n2951 0.0405
R5167 VDD.n410 VDD.n404 0.0405
R5168 VDD.n416 VDD.n404 0.0405
R5169 VDD.n434 VDD.n399 0.0405
R5170 VDD.n435 VDD.n434 0.0405
R5171 VDD.n396 VDD.n395 0.0400576
R5172 VDD.n1937 VDD.n1907 0.0399737
R5173 VDD.n1930 VDD.n1916 0.0399737
R5174 VDD.n1961 VDD.n1104 0.0399737
R5175 VDD.n1894 VDD.n1893 0.0399737
R5176 VDD.n1670 VDD.n1669 0.0399737
R5177 VDD.n1662 VDD.n1661 0.0399737
R5178 VDD.n1644 VDD.n1618 0.0399737
R5179 VDD.n1632 VDD.n1631 0.0399737
R5180 VDD.n1542 VDD.n1541 0.0399737
R5181 VDD.n1533 VDD.n1532 0.0399737
R5182 VDD.n1515 VDD.n1485 0.0399737
R5183 VDD.n1498 VDD.n1497 0.0399737
R5184 VDD.n2143 VDD.n2113 0.0399737
R5185 VDD.n2136 VDD.n2122 0.0399737
R5186 VDD.n2167 VDD.n2071 0.0399737
R5187 VDD.n2095 VDD.n2094 0.0399737
R5188 VDD.n2425 VDD.n2424 0.0399737
R5189 VDD.n2189 VDD.n2178 0.0399737
R5190 VDD.n2212 VDD.n2211 0.0399737
R5191 VDD.n2219 VDD.n1085 0.0399737
R5192 VDD.n1446 VDD.n1445 0.0399737
R5193 VDD.n1438 VDD.n1437 0.0399737
R5194 VDD.n1468 VDD.n1335 0.0399737
R5195 VDD.n1406 VDD.n1405 0.0399737
R5196 VDD.n1299 VDD.n1298 0.0399737
R5197 VDD.n1291 VDD.n1290 0.0399737
R5198 VDD.n1321 VDD.n1178 0.0399737
R5199 VDD.n1258 VDD.n1257 0.0399737
R5200 VDD.n2792 VDD.n2791 0.0399737
R5201 VDD.n2783 VDD.n2782 0.0399737
R5202 VDD.n2765 VDD.n183 0.0399737
R5203 VDD.n196 VDD.n195 0.0399737
R5204 VDD.n654 VDD.n586 0.0399737
R5205 VDD.n647 VDD.n595 0.0399737
R5206 VDD.n609 VDD.n606 0.0399737
R5207 VDD.n623 VDD.n622 0.0399737
R5208 VDD.n2916 VDD.n2886 0.0399737
R5209 VDD.n2909 VDD.n2895 0.0399737
R5210 VDD.n2940 VDD.n34 0.0399737
R5211 VDD.n51 VDD.n50 0.0399737
R5212 VDD.n2965 VDD.n18 0.0399737
R5213 VDD.n2958 VDD.n2956 0.0399737
R5214 VDD.n415 VDD.n403 0.0399737
R5215 VDD.n429 VDD.n424 0.0399737
R5216 VDD.n1548 VDD.n1547 0.0378832
R5217 VDD.n1547 VDD.n1150 0.0378832
R5218 VDD.n1531 VDD.n1530 0.0378832
R5219 VDD.n1530 VDD.n1169 0.0378832
R5220 VDD.n1520 VDD.n1484 0.0378832
R5221 VDD.n1486 VDD.n1484 0.0378832
R5222 VDD.n1508 VDD.n1493 0.0378832
R5223 VDD.n1502 VDD.n1493 0.0378832
R5224 VDD.n672 VDD.n671 0.0372647
R5225 VDD.n517 VDD.n512 0.0372647
R5226 VDD.n2036 VDD.n2005 0.0366842
R5227 VDD.n2748 VDD.n201 0.0348137
R5228 VDD.n2292 VDD.n2228 0.0345909
R5229 VDD.n1146 VDD.n1145 0.0345909
R5230 VDD.n1061 VDD.n1060 0.0345909
R5231 VDD.n569 VDD.n568 0.0323627
R5232 VDD.n1882 VDD.n1119 0.030803
R5233 VDD.n2803 VDD.n149 0.030803
R5234 VDD.n2613 VDD.n2612 0.030803
R5235 VDD.n2028 VDD.n2015 0.0301053
R5236 VDD.n2051 VDD.n1984 0.0301053
R5237 VDD.n2059 VDD 0.0284605
R5238 VDD.n1891 VDD 0.0284605
R5239 VDD VDD.n1619 0.0284605
R5240 VDD.n1494 VDD 0.0284605
R5241 VDD.n1276 VDD 0.0284605
R5242 VDD.n600 VDD 0.0284605
R5243 VDD.n518 VDD.n511 0.0274608
R5244 VDD.n1563 VDD.n1562 0.0270152
R5245 VDD.n1355 VDD.n1349 0.0270152
R5246 VDD.n2466 VDD.n1025 0.0270152
R5247 VDD.n2007 VDD.n2003 0.0268158
R5248 VDD.n2031 VDD.n2008 0.0268158
R5249 VDD.n2023 VDD.n2022 0.0268158
R5250 VDD.n2065 VDD.n1970 0.0268158
R5251 VDD.n2057 VDD.n1978 0.0268158
R5252 VDD.n2053 VDD.n1980 0.0268158
R5253 VDD.n1941 VDD.n1940 0.0268158
R5254 VDD.n1929 VDD.n1917 0.0268158
R5255 VDD.n1965 VDD.n1964 0.0268158
R5256 VDD.n1953 VDD.n1114 0.0268158
R5257 VDD.n1602 VDD.n1601 0.0268158
R5258 VDD.n1610 VDD.n1604 0.0268158
R5259 VDD.n1648 VDD.n1647 0.0268158
R5260 VDD.n1636 VDD.n1634 0.0268158
R5261 VDD.n1154 VDD.n1153 0.0268158
R5262 VDD.n1478 VDD.n1166 0.0268158
R5263 VDD.n1519 VDD.n1518 0.0268158
R5264 VDD.n1507 VDD.n1499 0.0268158
R5265 VDD.n2147 VDD.n2146 0.0268158
R5266 VDD.n2135 VDD.n2123 0.0268158
R5267 VDD.n2171 VDD.n2170 0.0268158
R5268 VDD.n2159 VDD.n2082 0.0268158
R5269 VDD.n1069 VDD.n1068 0.0268158
R5270 VDD.n2190 VDD.n2176 0.0268158
R5271 VDD.n2204 VDD.n2203 0.0268158
R5272 VDD.n2223 VDD.n2221 0.0268158
R5273 VDD.n1416 VDD.n1415 0.0268158
R5274 VDD.n1431 VDD.n1418 0.0268158
R5275 VDD.n1472 VDD.n1471 0.0268158
R5276 VDD.n1460 VDD.n1344 0.0268158
R5277 VDD.n1268 VDD.n1267 0.0268158
R5278 VDD.n1284 VDD.n1270 0.0268158
R5279 VDD.n1325 VDD.n1324 0.0268158
R5280 VDD.n1313 VDD.n1189 0.0268158
R5281 VDD.n157 VDD.n156 0.0268158
R5282 VDD.n176 VDD.n169 0.0268158
R5283 VDD.n2769 VDD.n2768 0.0268158
R5284 VDD.n2757 VDD.n197 0.0268158
R5285 VDD.n658 VDD.n657 0.0268158
R5286 VDD.n646 VDD.n596 0.0268158
R5287 VDD.n634 VDD.n602 0.0268158
R5288 VDD.n614 VDD.n612 0.0268158
R5289 VDD.n2920 VDD.n2919 0.0268158
R5290 VDD.n2908 VDD.n2896 0.0268158
R5291 VDD.n2944 VDD.n2943 0.0268158
R5292 VDD.n2932 VDD.n45 0.0268158
R5293 VDD.n2969 VDD.n2968 0.0268158
R5294 VDD.n2957 VDD.n0 0.0268158
R5295 VDD.n414 VDD.n411 0.0268158
R5296 VDD.n428 VDD.n425 0.0268158
R5297 VDD.n324 VDD 0.0264146
R5298 VDD.n2692 VDD.n2691 0.0263621
R5299 VDD.n1960 VDD 0.0251711
R5300 VDD.n1622 VDD 0.0251711
R5301 VDD.n1514 VDD 0.0251711
R5302 VDD.n1335 VDD 0.0251711
R5303 VDD.n2747 VDD.n199 0.0250098
R5304 VDD.n2040 VDD.n2039 0.0235263
R5305 VDD.n2063 VDD.n2062 0.0235263
R5306 VDD.n1946 VDD.n1945 0.0205
R5307 VDD.n1909 VDD.n1905 0.0205
R5308 VDD.n1932 VDD.n1910 0.0205
R5309 VDD.n1924 VDD.n1923 0.0205
R5310 VDD.n1967 VDD.n1101 0.0205
R5311 VDD.n1959 VDD.n1108 0.0205
R5312 VDD.n1955 VDD.n1110 0.0205
R5313 VDD.n1889 VDD.n1118 0.0205
R5314 VDD.n1597 VDD.n908 0.0205
R5315 VDD.n1672 VDD.n1671 0.0205
R5316 VDD.n1606 VDD.n1605 0.0205
R5317 VDD.n1656 VDD.n1655 0.0205
R5318 VDD.n1651 VDD.n1650 0.0205
R5319 VDD.n1642 VDD.n1621 0.0205
R5320 VDD.n1638 VDD.n1623 0.0205
R5321 VDD.n1683 VDD.n1585 0.0205
R5322 VDD.n2152 VDD.n2151 0.0205
R5323 VDD.n2115 VDD.n2111 0.0205
R5324 VDD.n2138 VDD.n2116 0.0205
R5325 VDD.n2130 VDD.n2129 0.0205
R5326 VDD.n2173 VDD.n2068 0.0205
R5327 VDD.n2165 VDD.n2076 0.0205
R5328 VDD.n2161 VDD.n2078 0.0205
R5329 VDD.n2087 VDD.n2086 0.0205
R5330 VDD.n2434 VDD.n1062 0.0205
R5331 VDD.n2427 VDD.n2426 0.0205
R5332 VDD.n2182 VDD.n2181 0.0205
R5333 VDD.n2183 VDD.n2175 0.0205
R5334 VDD.n2201 VDD.n1091 0.0205
R5335 VDD.n2214 VDD.n1086 0.0205
R5336 VDD.n2218 VDD.n1084 0.0205
R5337 VDD.n2418 VDD.n2227 0.0205
R5338 VDD.n1411 VDD.n824 0.0205
R5339 VDD.n1448 VDD.n1447 0.0205
R5340 VDD.n1420 VDD.n1419 0.0205
R5341 VDD.n1426 VDD.n1421 0.0205
R5342 VDD.n1474 VDD.n1330 0.0205
R5343 VDD.n1466 VDD.n1338 0.0205
R5344 VDD.n1462 VDD.n1340 0.0205
R5345 VDD.n1398 VDD.n1348 0.0205
R5346 VDD.n1263 VDD.n748 0.0205
R5347 VDD.n1301 VDD.n1300 0.0205
R5348 VDD.n1272 VDD.n1271 0.0205
R5349 VDD.n1279 VDD.n1273 0.0205
R5350 VDD.n1327 VDD.n1176 0.0205
R5351 VDD.n1319 VDD.n1183 0.0205
R5352 VDD.n1315 VDD.n1185 0.0205
R5353 VDD.n1250 VDD.n1193 0.0205
R5354 VDD.n2801 VDD.n150 0.0205
R5355 VDD.n2794 VDD.n2793 0.0205
R5356 VDD.n171 VDD.n170 0.0205
R5357 VDD.n2777 VDD.n2776 0.0205
R5358 VDD.n2772 VDD.n2771 0.0205
R5359 VDD.n2763 VDD.n186 0.0205
R5360 VDD.n2759 VDD.n188 0.0205
R5361 VDD.n2751 VDD.n2750 0.0205
R5362 VDD.n663 VDD.n662 0.0205
R5363 VDD.n588 VDD.n584 0.0205
R5364 VDD.n649 VDD.n589 0.0205
R5365 VDD.n641 VDD.n599 0.0205
R5366 VDD.n639 VDD.n601 0.0205
R5367 VDD.n629 VDD.n628 0.0205
R5368 VDD.n621 VDD.n620 0.0205
R5369 VDD.n669 VDD.n570 0.0205
R5370 VDD.n2925 VDD.n2924 0.0205
R5371 VDD.n2888 VDD.n2884 0.0205
R5372 VDD.n2911 VDD.n2889 0.0205
R5373 VDD.n2903 VDD.n2902 0.0205
R5374 VDD.n2946 VDD.n31 0.0205
R5375 VDD.n2938 VDD.n39 0.0205
R5376 VDD.n2934 VDD.n41 0.0205
R5377 VDD.n515 VDD.n514 0.0205
R5378 VDD.n2974 VDD.n2973 0.0205
R5379 VDD.n20 VDD.n16 0.0205
R5380 VDD.n2960 VDD.n21 0.0205
R5381 VDD.n2950 VDD.n23 0.0205
R5382 VDD.n406 VDD.n25 0.0205
R5383 VDD.n419 VDD.n418 0.0205
R5384 VDD.n431 VDD.n430 0.0205
R5385 VDD.n438 VDD.n397 0.0205
R5386 VDD.n440 VDD.n265 0.0201078
R5387 VDD.n2416 VDD.n2415 0.0194394
R5388 VDD.n1740 VDD.n1739 0.0194394
R5389 VDD.n528 VDD.n60 0.0194394
R5390 VDD.n1554 VDD.n1553 0.0194394
R5391 VDD.n1551 VDD.n1147 0.0191916
R5392 VDD.n1544 VDD.n1543 0.0191916
R5393 VDD.n1168 VDD.n1167 0.0191916
R5394 VDD.n1527 VDD.n1526 0.0191916
R5395 VDD.n1522 VDD.n1521 0.0191916
R5396 VDD.n1513 VDD.n1487 0.0191916
R5397 VDD.n1509 VDD.n1489 0.0191916
R5398 VDD.n1501 VDD.n1134 0.0191916
R5399 VDD.n2025 VDD.n2024 0.0169474
R5400 VDD.n2050 VDD.n1985 0.0169474
R5401 VDD.n2174 VDD.n1093 0.0159605
R5402 VDD.n2200 VDD.n1088 0.0159605
R5403 VDD.n1887 VDD.n1886 0.0156515
R5404 VDD.n2804 VDD.n148 0.0156515
R5405 VDD.n2610 VDD.n823 0.0156515
R5406 VDD VDD.n2773 0.0153026
R5407 VDD.n2904 VDD 0.0153026
R5408 VDD.n1906 VDD.n1902 0.0136579
R5409 VDD.n1926 VDD.n1925 0.0136579
R5410 VDD.n1920 VDD.n1103 0.0136579
R5411 VDD.n1952 VDD.n1115 0.0136579
R5412 VDD.n1677 VDD.n1596 0.0136579
R5413 VDD.n1654 VDD.n1613 0.0136579
R5414 VDD.n1652 VDD.n1616 0.0136579
R5415 VDD.n1635 VDD.n1586 0.0136579
R5416 VDD.n1549 VDD.n1149 0.0136579
R5417 VDD.n1525 VDD.n1480 0.0136579
R5418 VDD.n1523 VDD.n1483 0.0136579
R5419 VDD.n1506 VDD.n1503 0.0136579
R5420 VDD.n2112 VDD.n2099 0.0136579
R5421 VDD.n2126 VDD.n2070 0.0136579
R5422 VDD.n2158 VDD.n2083 0.0136579
R5423 VDD.n2432 VDD.n1064 0.0136579
R5424 VDD.n2197 VDD.n1090 0.0136579
R5425 VDD.n2222 VDD.n1081 0.0136579
R5426 VDD.n1453 VDD.n1410 0.0136579
R5427 VDD.n1430 VDD.n1427 0.0136579
R5428 VDD.n1424 VDD.n1332 0.0136579
R5429 VDD.n1459 VDD.n1345 0.0136579
R5430 VDD.n1306 VDD.n1262 0.0136579
R5431 VDD.n1283 VDD.n1280 0.0136579
R5432 VDD.n1277 VDD.n1276 0.0136579
R5433 VDD.n1312 VDD.n1190 0.0136579
R5434 VDD.n2799 VDD.n152 0.0136579
R5435 VDD.n2775 VDD.n178 0.0136579
R5436 VDD.n2773 VDD.n181 0.0136579
R5437 VDD.n2756 VDD.n2753 0.0136579
R5438 VDD.n585 VDD.n581 0.0136579
R5439 VDD.n643 VDD.n642 0.0136579
R5440 VDD.n638 VDD.n637 0.0136579
R5441 VDD.n613 VDD.n571 0.0136579
R5442 VDD.n2885 VDD.n59 0.0136579
R5443 VDD.n2905 VDD.n2904 0.0136579
R5444 VDD.n2899 VDD.n33 0.0136579
R5445 VDD.n2931 VDD.n46 0.0136579
R5446 VDD.n17 VDD.n12 0.0136579
R5447 VDD.n2980 VDD.n1 0.0136579
R5448 VDD.n409 VDD.n407 0.0136579
R5449 VDD.n436 VDD.n398 0.0136579
R5450 VDD.n2066 VDD.n1095 0.0134868
R5451 VDD.n1968 VDD.n1098 0.0134868
R5452 VDD.n1657 VDD.n1099 0.0134868
R5453 VDD.n1528 VDD.n1476 0.0134868
R5454 VDD.n1475 VDD.n1172 0.0134868
R5455 VDD.n1328 VDD.n1174 0.0134868
R5456 VDD.n2778 VDD.n174 0.0134868
R5457 VDD.n598 VDD.n30 0.0134868
R5458 VDD.n2947 VDD.n28 0.0134868
R5459 VDD.n2949 VDD.n2948 0.0134868
R5460 VDD.n2948 VDD.n24 0.01225
R5461 VDD.n2066 VDD.n1096 0.01225
R5462 VDD.n1968 VDD.n1097 0.01225
R5463 VDD.n1624 VDD.n1099 0.01225
R5464 VDD.n1490 VDD.n1476 0.01225
R5465 VDD.n1475 VDD.n1171 0.01225
R5466 VDD.n1328 VDD.n1173 0.01225
R5467 VDD.n189 VDD.n174 0.01225
R5468 VDD.n631 VDD.n30 0.01225
R5469 VDD.n2947 VDD.n27 0.01225
R5470 VDD.n1565 VDD.n1133 0.0118636
R5471 VDD.n1396 VDD.n1350 0.0118636
R5472 VDD.n2107 VDD.n2100 0.0118636
R5473 VDD.n2004 VDD.n2000 0.0103684
R5474 VDD.n2016 VDD.n1972 0.0103684
R5475 VDD VDD.n2131 0.0103684
R5476 VDD.n2194 VDD 0.0103684
R5477 VDD.n2174 VDD.n1094 0.00977632
R5478 VDD.n2200 VDD.n1092 0.00977632
R5479 VDD.n2342 VDD.n2293 0.00912069
R5480 VDD.n2307 VDD.n2248 0.00912069
R5481 VDD VDD.n1973 0.00872368
R5482 VDD.n2880 VDD.n61 0.00428788
R5483 VDD.n2020 VDD.n2017 0.00378947
R5484 VDD.n2132 VDD 0.00378947
R5485 VDD VDD.n2193 0.00378947
R5486 VDD.n305 VDD.n304 0.00353712
R5487 VDD.n2252 VDD.n2248 0.00348286
R5488 VSS.n1523 VSS.n1522 586.324
R5489 VSS.n966 VSS.n965 585
R5490 VSS.n965 VSS.n964 585
R5491 VSS.n918 VSS.n917 585
R5492 VSS.n917 VSS.n916 585
R5493 VSS.n973 VSS.n972 585
R5494 VSS.n974 VSS.n973 585
R5495 VSS.n903 VSS.n901 585
R5496 VSS.n904 VSS.n903 585
R5497 VSS.n1000 VSS.n999 585
R5498 VSS.n999 VSS.n998 585
R5499 VSS.n902 VSS.n897 585
R5500 VSS.n897 VSS.n896 585
R5501 VSS.n1006 VSS.n1005 585
R5502 VSS.n1007 VSS.n1006 585
R5503 VSS.n899 VSS.n878 585
R5504 VSS.n879 VSS.n878 585
R5505 VSS.n1031 VSS.n1030 585
R5506 VSS.n1030 VSS.n1029 585
R5507 VSS.n1032 VSS.n873 585
R5508 VSS.n873 VSS.n871 585
R5509 VSS.n1039 VSS.n1038 585
R5510 VSS.n1040 VSS.n1039 585
R5511 VSS.n875 VSS.n855 585
R5512 VSS.n872 VSS.n855 585
R5513 VSS.n1068 VSS.n1067 585
R5514 VSS.n1067 VSS.n1066 585
R5515 VSS.n1069 VSS.n850 585
R5516 VSS.n850 VSS.n849 585
R5517 VSS.n1076 VSS.n1075 585
R5518 VSS.n1077 VSS.n1076 585
R5519 VSS.n852 VSS.n830 585
R5520 VSS.n831 VSS.n830 585
R5521 VSS.n1106 VSS.n1105 585
R5522 VSS.n1105 VSS.n1104 585
R5523 VSS.n1107 VSS.n825 585
R5524 VSS.n825 VSS.n824 585
R5525 VSS.n1114 VSS.n1113 585
R5526 VSS.n1115 VSS.n1114 585
R5527 VSS.n827 VSS.n810 585
R5528 VSS.n811 VSS.n810 585
R5529 VSS.n1137 VSS.n1136 585
R5530 VSS.n1136 VSS.n1135 585
R5531 VSS.n807 VSS.n805 585
R5532 VSS.n805 VSS.n804 585
R5533 VSS.n1146 VSS.n1145 585
R5534 VSS.n1147 VSS.n1146 585
R5535 VSS.n1144 VSS.n806 585
R5536 VSS.n806 VSS.n794 585
R5537 VSS.n1141 VSS.n765 585
R5538 VSS.n1160 VSS.n765 585
R5539 VSS.n1159 VSS.n1158 585
R5540 VSS.n1160 VSS.n1159 585
R5541 VSS.n802 VSS.n795 585
R5542 VSS.n795 VSS.n794 585
R5543 VSS.n1149 VSS.n1148 585
R5544 VSS.n1148 VSS.n1147 585
R5545 VSS.n803 VSS.n801 585
R5546 VSS.n804 VSS.n803 585
R5547 VSS.n1134 VSS.n1133 585
R5548 VSS.n1135 VSS.n1134 585
R5549 VSS.n1118 VSS.n812 585
R5550 VSS.n812 VSS.n811 585
R5551 VSS.n1117 VSS.n1116 585
R5552 VSS.n1116 VSS.n1115 585
R5553 VSS.n834 VSS.n823 585
R5554 VSS.n824 VSS.n823 585
R5555 VSS.n1103 VSS.n1102 585
R5556 VSS.n1104 VSS.n1103 585
R5557 VSS.n846 VSS.n832 585
R5558 VSS.n832 VSS.n831 585
R5559 VSS.n1079 VSS.n1078 585
R5560 VSS.n1078 VSS.n1077 585
R5561 VSS.n848 VSS.n845 585
R5562 VSS.n849 VSS.n848 585
R5563 VSS.n1065 VSS.n1064 585
R5564 VSS.n1066 VSS.n1065 585
R5565 VSS.n868 VSS.n856 585
R5566 VSS.n872 VSS.n856 585
R5567 VSS.n1042 VSS.n1041 585
R5568 VSS.n1041 VSS.n1040 585
R5569 VSS.n870 VSS.n867 585
R5570 VSS.n871 VSS.n870 585
R5571 VSS.n1028 VSS.n1027 585
R5572 VSS.n1029 VSS.n1028 585
R5573 VSS.n893 VSS.n880 585
R5574 VSS.n880 VSS.n879 585
R5575 VSS.n1009 VSS.n1008 585
R5576 VSS.n1008 VSS.n1007 585
R5577 VSS.n895 VSS.n892 585
R5578 VSS.n896 VSS.n895 585
R5579 VSS.n997 VSS.n996 585
R5580 VSS.n998 VSS.n997 585
R5581 VSS.n906 VSS.n905 585
R5582 VSS.n905 VSS.n904 585
R5583 VSS.n976 VSS.n975 585
R5584 VSS.n975 VSS.n974 585
R5585 VSS.n915 VSS.n913 585
R5586 VSS.n916 VSS.n915 585
R5587 VSS.n963 VSS.n962 585
R5588 VSS.n964 VSS.n963 585
R5589 VSS.n932 VSS.n921 585
R5590 VSS.n939 VSS.n937 585
R5591 VSS.n940 VSS.n931 585
R5592 VSS.n940 VSS.n922 585
R5593 VSS.n943 VSS.n942 585
R5594 VSS.n929 VSS.n928 585
R5595 VSS.n950 VSS.n949 585
R5596 VSS.n952 VSS.n927 585
R5597 VSS.n955 VSS.n954 585
R5598 VSS.n924 VSS.n923 585
R5599 VSS.n1524 VSS.n1523 585
R5600 VSS.n1197 VSS.n755 585
R5601 VSS.n1526 VSS.n755 585
R5602 VSS.n1529 VSS.n1528 585
R5603 VSS.n1528 VSS.n1527 585
R5604 VSS.n751 VSS.n748 585
R5605 VSS.n748 VSS.n747 585
R5606 VSS.n1535 VSS.n1534 585
R5607 VSS.n1536 VSS.n1535 585
R5608 VSS.n749 VSS.n742 585
R5609 VSS.n1537 VSS.n742 585
R5610 VSS.n1540 VSS.n1539 585
R5611 VSS.n1539 VSS.n1538 585
R5612 VSS.n741 VSS.n739 585
R5613 VSS.n743 VSS.n741 585
R5614 VSS.n1474 VSS.n1473 585
R5615 VSS.n1475 VSS.n1474 585
R5616 VSS.n1223 VSS.n1222 585
R5617 VSS.n1222 VSS.n1221 585
R5618 VSS.n1467 VSS.n1466 585
R5619 VSS.n1466 VSS.n1465 585
R5620 VSS.n1452 VSS.n1226 585
R5621 VSS.n1227 VSS.n1226 585
R5622 VSS.n1454 VSS.n1453 585
R5623 VSS.n1455 VSS.n1454 585
R5624 VSS.n1237 VSS.n1236 585
R5625 VSS.n1236 VSS.n1235 585
R5626 VSS.n1447 VSS.n1446 585
R5627 VSS.n1446 VSS.n1445 585
R5628 VSS.n1250 VSS.n1240 585
R5629 VSS.n1241 VSS.n1240 585
R5630 VSS.n1434 VSS.n1433 585
R5631 VSS.n1435 VSS.n1434 585
R5632 VSS.n1427 VSS.n1248 585
R5633 VSS.n1248 VSS.n1247 585
R5634 VSS.n1426 VSS.n1425 585
R5635 VSS.n1425 VSS.n1424 585
R5636 VSS.n1280 VSS.n1269 585
R5637 VSS.n1277 VSS.n1269 585
R5638 VSS.n1412 VSS.n1411 585
R5639 VSS.n1413 VSS.n1412 585
R5640 VSS.n1405 VSS.n1278 585
R5641 VSS.n1278 VSS.n1276 585
R5642 VSS.n1404 VSS.n1403 585
R5643 VSS.n1403 VSS.n1402 585
R5644 VSS.n1285 VSS.n1284 585
R5645 VSS.n1286 VSS.n1285 585
R5646 VSS.n703 VSS.n700 585
R5647 VSS.n700 VSS.n699 585
R5648 VSS.n1576 VSS.n1575 585
R5649 VSS.n1577 VSS.n1576 585
R5650 VSS.n701 VSS.n695 585
R5651 VSS.n1578 VSS.n695 585
R5652 VSS.n1581 VSS.n1580 585
R5653 VSS.n1580 VSS.n1579 585
R5654 VSS.n694 VSS.n690 585
R5655 VSS.n1381 VSS.n694 585
R5656 VSS.n1586 VSS.n687 585
R5657 VSS.n687 VSS.n686 585
R5658 VSS.n1588 VSS.n1587 585
R5659 VSS.n1589 VSS.n1588 585
R5660 VSS.n688 VSS.n682 585
R5661 VSS.n1590 VSS.n682 585
R5662 VSS.n1593 VSS.n1592 585
R5663 VSS.n1592 VSS.n1591 585
R5664 VSS.n677 VSS.n674 585
R5665 VSS.n674 VSS.n673 585
R5666 VSS.n1599 VSS.n1598 585
R5667 VSS.n1600 VSS.n1599 585
R5668 VSS.n675 VSS.n669 585
R5669 VSS.n1601 VSS.n669 585
R5670 VSS.n1604 VSS.n1603 585
R5671 VSS.n1603 VSS.n1602 585
R5672 VSS.n665 VSS.n663 585
R5673 VSS.n663 VSS.n662 585
R5674 VSS.n1610 VSS.n1609 585
R5675 VSS.n1611 VSS.n1610 585
R5676 VSS.n1317 VSS.n657 585
R5677 VSS.n1612 VSS.n657 585
R5678 VSS.n1614 VSS.n658 585
R5679 VSS.n1614 VSS.n1613 585
R5680 VSS.n1615 VSS.n655 585
R5681 VSS.n1616 VSS.n1615 585
R5682 VSS.n1316 VSS.n656 585
R5683 VSS.n1328 VSS.n1326 585
R5684 VSS.n1329 VSS.n1314 585
R5685 VSS.n1329 VSS.n654 585
R5686 VSS.n1332 VSS.n1331 585
R5687 VSS.n1315 VSS.n1305 585
R5688 VSS.n1345 VSS.n1344 585
R5689 VSS.n1347 VSS.n1304 585
R5690 VSS.n1349 VSS.n1348 585
R5691 VSS.n1348 VSS.n654 585
R5692 VSS.n1500 VSS.n1499 585
R5693 VSS.n1504 VSS.n1503 585
R5694 VSS.n1502 VSS.n1211 585
R5695 VSS.n1209 VSS.n1208 585
R5696 VSS.n1207 VSS.n1202 585
R5697 VSS.n1514 VSS.n1513 585
R5698 VSS.n1516 VSS.n1515 585
R5699 VSS.n1200 VSS.n1199 585
R5700 VSS.n1212 VSS.n762 585
R5701 VSS.n1524 VSS.n762 585
R5702 VSS.n1493 VSS.n757 585
R5703 VSS.n1526 VSS.n757 585
R5704 VSS.n1492 VSS.n756 585
R5705 VSS.n1527 VSS.n756 585
R5706 VSS.n1490 VSS.n1489 585
R5707 VSS.n1489 VSS.n747 585
R5708 VSS.n1214 VSS.n746 585
R5709 VSS.n1536 VSS.n746 585
R5710 VSS.n1484 VSS.n745 585
R5711 VSS.n1537 VSS.n745 585
R5712 VSS.n1482 VSS.n744 585
R5713 VSS.n1538 VSS.n744 585
R5714 VSS.n1220 VSS.n1216 585
R5715 VSS.n1220 VSS.n743 585
R5716 VSS.n1477 VSS.n1476 585
R5717 VSS.n1476 VSS.n1475 585
R5718 VSS.n1230 VSS.n1219 585
R5719 VSS.n1221 VSS.n1219 585
R5720 VSS.n1464 VSS.n1463 585
R5721 VSS.n1465 VSS.n1464 585
R5722 VSS.n1233 VSS.n1228 585
R5723 VSS.n1228 VSS.n1227 585
R5724 VSS.n1457 VSS.n1456 585
R5725 VSS.n1456 VSS.n1455 585
R5726 VSS.n1234 VSS.n1232 585
R5727 VSS.n1235 VSS.n1234 585
R5728 VSS.n1444 VSS.n1443 585
R5729 VSS.n1445 VSS.n1444 585
R5730 VSS.n1243 VSS.n1242 585
R5731 VSS.n1242 VSS.n1241 585
R5732 VSS.n1437 VSS.n1436 585
R5733 VSS.n1436 VSS.n1435 585
R5734 VSS.n1272 VSS.n1246 585
R5735 VSS.n1247 VSS.n1246 585
R5736 VSS.n1423 VSS.n1422 585
R5737 VSS.n1424 VSS.n1423 585
R5738 VSS.n1416 VSS.n1270 585
R5739 VSS.n1277 VSS.n1270 585
R5740 VSS.n1415 VSS.n1414 585
R5741 VSS.n1414 VSS.n1413 585
R5742 VSS.n1289 VSS.n1275 585
R5743 VSS.n1276 VSS.n1275 585
R5744 VSS.n1401 VSS.n1400 585
R5745 VSS.n1402 VSS.n1401 585
R5746 VSS.n1394 VSS.n1287 585
R5747 VSS.n1287 VSS.n1286 585
R5748 VSS.n1393 VSS.n1392 585
R5749 VSS.n1392 VSS.n699 585
R5750 VSS.n1390 VSS.n698 585
R5751 VSS.n1577 VSS.n698 585
R5752 VSS.n1291 VSS.n697 585
R5753 VSS.n1578 VSS.n697 585
R5754 VSS.n1385 VSS.n696 585
R5755 VSS.n1579 VSS.n696 585
R5756 VSS.n1383 VSS.n1382 585
R5757 VSS.n1382 VSS.n1381 585
R5758 VSS.n1380 VSS.n1379 585
R5759 VSS.n1380 VSS.n686 585
R5760 VSS.n1378 VSS.n685 585
R5761 VSS.n1589 VSS.n685 585
R5762 VSS.n1294 VSS.n684 585
R5763 VSS.n1590 VSS.n684 585
R5764 VSS.n1372 VSS.n683 585
R5765 VSS.n1591 VSS.n683 585
R5766 VSS.n1370 VSS.n1369 585
R5767 VSS.n1369 VSS.n673 585
R5768 VSS.n1296 VSS.n672 585
R5769 VSS.n1600 VSS.n672 585
R5770 VSS.n1364 VSS.n671 585
R5771 VSS.n1601 VSS.n671 585
R5772 VSS.n1362 VSS.n670 585
R5773 VSS.n1602 VSS.n670 585
R5774 VSS.n1299 VSS.n1298 585
R5775 VSS.n1298 VSS.n662 585
R5776 VSS.n1357 VSS.n661 585
R5777 VSS.n1611 VSS.n661 585
R5778 VSS.n1355 VSS.n660 585
R5779 VSS.n1612 VSS.n660 585
R5780 VSS.n1301 VSS.n659 585
R5781 VSS.n1613 VSS.n659 585
R5782 VSS.n1351 VSS.n653 585
R5783 VSS.n1616 VSS.n653 585
R5784 VSS.n1700 VSS.n1699 585
R5785 VSS.n1701 VSS.n1700 585
R5786 VSS.n640 VSS.n637 585
R5787 VSS.n1702 VSS.n637 585
R5788 VSS.n1705 VSS.n1704 585
R5789 VSS.n1704 VSS.n1703 585
R5790 VSS.n633 VSS.n630 585
R5791 VSS.n630 VSS.n629 585
R5792 VSS.n1711 VSS.n1710 585
R5793 VSS.n1712 VSS.n1711 585
R5794 VSS.n631 VSS.n628 585
R5795 VSS.n1713 VSS.n628 585
R5796 VSS.n1716 VSS.n1715 585
R5797 VSS.n1715 VSS.n1714 585
R5798 VSS.n624 VSS.n621 585
R5799 VSS.n621 VSS.n620 585
R5800 VSS.n1722 VSS.n1721 585
R5801 VSS.n1723 VSS.n1722 585
R5802 VSS.n622 VSS.n618 585
R5803 VSS.n1724 VSS.n618 585
R5804 VSS.n1727 VSS.n1726 585
R5805 VSS.n1726 VSS.n1725 585
R5806 VSS.n617 VSS.n613 585
R5807 VSS.n619 VSS.n617 585
R5808 VSS.n1732 VSS.n610 585
R5809 VSS.n610 VSS.n609 585
R5810 VSS.n1734 VSS.n1733 585
R5811 VSS.n1735 VSS.n1734 585
R5812 VSS.n611 VSS.n608 585
R5813 VSS.n1736 VSS.n608 585
R5814 VSS.n1739 VSS.n1738 585
R5815 VSS.n1738 VSS.n1737 585
R5816 VSS.n604 VSS.n601 585
R5817 VSS.n601 VSS.n600 585
R5818 VSS.n1745 VSS.n1744 585
R5819 VSS.n1746 VSS.n1745 585
R5820 VSS.n602 VSS.n599 585
R5821 VSS.n1747 VSS.n599 585
R5822 VSS.n1750 VSS.n1749 585
R5823 VSS.n1749 VSS.n1748 585
R5824 VSS.n595 VSS.n592 585
R5825 VSS.n592 VSS.n591 585
R5826 VSS.n1756 VSS.n1755 585
R5827 VSS.n1757 VSS.n1756 585
R5828 VSS.n593 VSS.n590 585
R5829 VSS.n1758 VSS.n590 585
R5830 VSS.n1761 VSS.n1760 585
R5831 VSS.n1760 VSS.n1759 585
R5832 VSS.n586 VSS.n583 585
R5833 VSS.n583 VSS.n582 585
R5834 VSS.n1767 VSS.n1766 585
R5835 VSS.n1768 VSS.n1767 585
R5836 VSS.n584 VSS.n581 585
R5837 VSS.n1769 VSS.n581 585
R5838 VSS.n1772 VSS.n1771 585
R5839 VSS.n1771 VSS.n1770 585
R5840 VSS.n578 VSS.n576 585
R5841 VSS.n576 VSS.n575 585
R5842 VSS.n1778 VSS.n1777 585
R5843 VSS.n1779 VSS.n1778 585
R5844 VSS.n574 VSS.n573 585
R5845 VSS.n1780 VSS.n574 585
R5846 VSS.n1783 VSS.n1782 585
R5847 VSS.n1782 VSS.n1781 585
R5848 VSS.n570 VSS.n567 585
R5849 VSS.n567 VSS.n566 585
R5850 VSS.n1789 VSS.n1788 585
R5851 VSS.n1790 VSS.n1789 585
R5852 VSS.n568 VSS.n564 585
R5853 VSS.n1791 VSS.n564 585
R5854 VSS.n1794 VSS.n1793 585
R5855 VSS.n1793 VSS.n1792 585
R5856 VSS.n560 VSS.n557 585
R5857 VSS.n557 VSS.n556 585
R5858 VSS.n1800 VSS.n1799 585
R5859 VSS.n1801 VSS.n1800 585
R5860 VSS.n558 VSS.n555 585
R5861 VSS.n1802 VSS.n555 585
R5862 VSS.n1805 VSS.n1804 585
R5863 VSS.n1804 VSS.n1803 585
R5864 VSS.n551 VSS.n548 585
R5865 VSS.n548 VSS.n547 585
R5866 VSS.n1811 VSS.n1810 585
R5867 VSS.n1812 VSS.n1811 585
R5868 VSS.n549 VSS.n546 585
R5869 VSS.n1813 VSS.n546 585
R5870 VSS.n1816 VSS.n1815 585
R5871 VSS.n1815 VSS.n1814 585
R5872 VSS.n542 VSS.n539 585
R5873 VSS.n539 VSS.n538 585
R5874 VSS.n1822 VSS.n1821 585
R5875 VSS.n1823 VSS.n1822 585
R5876 VSS.n540 VSS.n536 585
R5877 VSS.n1824 VSS.n536 585
R5878 VSS.n1827 VSS.n1826 585
R5879 VSS.n1826 VSS.n1825 585
R5880 VSS.n535 VSS.n533 585
R5881 VSS.n537 VSS.n535 585
R5882 VSS.n530 VSS.n527 585
R5883 VSS.n527 VSS.n526 585
R5884 VSS.n1833 VSS.n1832 585
R5885 VSS.n1834 VSS.n1833 585
R5886 VSS.n528 VSS.n525 585
R5887 VSS.n1835 VSS.n525 585
R5888 VSS.n1838 VSS.n1837 585
R5889 VSS.n1837 VSS.n1836 585
R5890 VSS.n521 VSS.n518 585
R5891 VSS.n518 VSS.n517 585
R5892 VSS.n1844 VSS.n1843 585
R5893 VSS.n1845 VSS.n1844 585
R5894 VSS.n519 VSS.n516 585
R5895 VSS.n1846 VSS.n516 585
R5896 VSS.n1849 VSS.n1848 585
R5897 VSS.n1848 VSS.n1847 585
R5898 VSS.n512 VSS.n509 585
R5899 VSS.n509 VSS.n508 585
R5900 VSS.n1855 VSS.n1854 585
R5901 VSS.n1856 VSS.n1855 585
R5902 VSS.n510 VSS.n506 585
R5903 VSS.n1857 VSS.n506 585
R5904 VSS.n1860 VSS.n1859 585
R5905 VSS.n1859 VSS.n1858 585
R5906 VSS.n503 VSS.n502 585
R5907 VSS.n507 VSS.n502 585
R5908 VSS.n1192 VSS.n1191 585
R5909 VSS.n767 VSS.n764 585
R5910 VSS.n1164 VSS.n1163 585
R5911 VSS.n797 VSS.n793 585
R5912 VSS.n788 VSS.n785 585
R5913 VSS.n785 VSS.n784 585
R5914 VSS.n1171 VSS.n1170 585
R5915 VSS.n1172 VSS.n1171 585
R5916 VSS.n786 VSS.n783 585
R5917 VSS.n1173 VSS.n783 585
R5918 VSS.n1176 VSS.n1175 585
R5919 VSS.n1175 VSS.n1174 585
R5920 VSS.n1177 VSS.n774 585
R5921 VSS.n774 VSS.n773 585
R5922 VSS.n1179 VSS.n1178 585
R5923 VSS.n1180 VSS.n1179 585
R5924 VSS.n777 VSS.n771 585
R5925 VSS.n1181 VSS.n771 585
R5926 VSS.n1183 VSS.n772 585
R5927 VSS.n1183 VSS.n1182 585
R5928 VSS.n1185 VSS.n1184 585
R5929 VSS.n1184 VSS.n763 585
R5930 VSS.n2122 VSS.n2121 585
R5931 VSS.n2123 VSS.n2122 585
R5932 VSS.n355 VSS.n331 585
R5933 VSS.n2124 VSS.n331 585
R5934 VSS.n354 VSS.n330 585
R5935 VSS.n2125 VSS.n330 585
R5936 VSS.n352 VSS.n351 585
R5937 VSS.n351 VSS.n25 585
R5938 VSS.n350 VSS.n24 585
R5939 VSS.n2133 VSS.n24 585
R5940 VSS.n338 VSS.n23 585
R5941 VSS.n2134 VSS.n23 585
R5942 VSS.n343 VSS.n22 585
R5943 VSS.n2135 VSS.n22 585
R5944 VSS.n341 VSS.n11 585
R5945 VSS.n13 VSS.n11 585
R5946 VSS.n2146 VSS.n2145 585
R5947 VSS.n2145 VSS.n2144 585
R5948 VSS.n1688 VSS.n1687 585
R5949 VSS.n652 VSS.n651 585
R5950 VSS.n1674 VSS.n1673 585
R5951 VSS.n1676 VSS.n1675 585
R5952 VSS.n1678 VSS.n1677 585
R5953 VSS.n1622 VSS.n1620 585
R5954 VSS.n1684 VSS.n1683 585
R5955 VSS.n1685 VSS.n1684 585
R5956 VSS.n1667 VSS.n1619 585
R5957 VSS.n1619 VSS.n482 585
R5958 VSS.n1666 VSS.n481 585
R5959 VSS.n1888 VSS.n481 585
R5960 VSS.n1664 VSS.n480 585
R5961 VSS.n1889 VSS.n480 585
R5962 VSS.n1624 VSS.n479 585
R5963 VSS.n1890 VSS.n479 585
R5964 VSS.n1659 VSS.n1658 585
R5965 VSS.n1658 VSS.n470 585
R5966 VSS.n1656 VSS.n469 585
R5967 VSS.n1899 VSS.n469 585
R5968 VSS.n1626 VSS.n468 585
R5969 VSS.n1900 VSS.n468 585
R5970 VSS.n1651 VSS.n467 585
R5971 VSS.n1901 VSS.n467 585
R5972 VSS.n1649 VSS.n1648 585
R5973 VSS.n1648 VSS.n458 585
R5974 VSS.n1628 VSS.n457 585
R5975 VSS.n1910 VSS.n457 585
R5976 VSS.n1643 VSS.n456 585
R5977 VSS.n1911 VSS.n456 585
R5978 VSS.n1641 VSS.n455 585
R5979 VSS.n1912 VSS.n455 585
R5980 VSS.n1631 VSS.n1630 585
R5981 VSS.n1630 VSS.n448 585
R5982 VSS.n1637 VSS.n447 585
R5983 VSS.n1920 VSS.n447 585
R5984 VSS.n1636 VSS.n446 585
R5985 VSS.n1921 VSS.n446 585
R5986 VSS.n1634 VSS.n445 585
R5987 VSS.n1922 VSS.n445 585
R5988 VSS.n1698 VSS.n639 585
R5989 VSS.n639 VSS.n638 585
R5990 VSS.n1931 VSS.n1930 585
R5991 VSS.n1934 VSS.n1933 585
R5992 VSS.n431 VSS.n430 585
R5993 VSS.n430 VSS.n333 585
R5994 VSS.n1939 VSS.n1938 585
R5995 VSS.n1941 VSS.n429 585
R5996 VSS.n1944 VSS.n1943 585
R5997 VSS.n1945 VSS.n425 585
R5998 VSS.n1952 VSS.n1951 585
R5999 VSS.n1954 VSS.n424 585
R6000 VSS.n1957 VSS.n1956 585
R6001 VSS.n1958 VSS.n420 585
R6002 VSS.n1965 VSS.n1964 585
R6003 VSS.n1967 VSS.n419 585
R6004 VSS.n1970 VSS.n1969 585
R6005 VSS.n1971 VSS.n415 585
R6006 VSS.n1978 VSS.n1977 585
R6007 VSS.n1980 VSS.n414 585
R6008 VSS.n1983 VSS.n1982 585
R6009 VSS.n411 VSS.n410 585
R6010 VSS.n1990 VSS.n1989 585
R6011 VSS.n1992 VSS.n409 585
R6012 VSS.n1996 VSS.n1994 585
R6013 VSS.n1995 VSS.n406 585
R6014 VSS.n2002 VSS.n2001 585
R6015 VSS.n2004 VSS.n405 585
R6016 VSS.n2007 VSS.n2006 585
R6017 VSS.n2008 VSS.n401 585
R6018 VSS.n2015 VSS.n2014 585
R6019 VSS.n2017 VSS.n400 585
R6020 VSS.n2020 VSS.n2019 585
R6021 VSS.n2021 VSS.n396 585
R6022 VSS.n2028 VSS.n2027 585
R6023 VSS.n2030 VSS.n395 585
R6024 VSS.n2033 VSS.n2032 585
R6025 VSS.n2034 VSS.n391 585
R6026 VSS.n2041 VSS.n2040 585
R6027 VSS.n2043 VSS.n390 585
R6028 VSS.n2046 VSS.n2045 585
R6029 VSS.n387 VSS.n386 585
R6030 VSS.n2051 VSS.n2050 585
R6031 VSS.n2053 VSS.n385 585
R6032 VSS.n2056 VSS.n2055 585
R6033 VSS.n2057 VSS.n381 585
R6034 VSS.n2064 VSS.n2063 585
R6035 VSS.n2066 VSS.n380 585
R6036 VSS.n2069 VSS.n2068 585
R6037 VSS.n2070 VSS.n376 585
R6038 VSS.n2077 VSS.n2076 585
R6039 VSS.n2079 VSS.n375 585
R6040 VSS.n2082 VSS.n2081 585
R6041 VSS.n2083 VSS.n371 585
R6042 VSS.n2090 VSS.n2089 585
R6043 VSS.n2092 VSS.n370 585
R6044 VSS.n2095 VSS.n2094 585
R6045 VSS.n367 VSS.n366 585
R6046 VSS.n2102 VSS.n2101 585
R6047 VSS.n2104 VSS.n365 585
R6048 VSS.n2107 VSS.n2106 585
R6049 VSS.n363 VSS.n362 585
R6050 VSS.n2112 VSS.n2111 585
R6051 VSS.n2115 VSS.n2114 585
R6052 VSS.n2143 VSS.n2142 585
R6053 VSS.n2144 VSS.n2143 585
R6054 VSS.n17 VSS.n15 585
R6055 VSS.n15 VSS.n13 585
R6056 VSS.n2137 VSS.n2136 585
R6057 VSS.n2136 VSS.n2135 585
R6058 VSS.n27 VSS.n21 585
R6059 VSS.n2134 VSS.n21 585
R6060 VSS.n2132 VSS.n2131 585
R6061 VSS.n2133 VSS.n2132 585
R6062 VSS.n28 VSS.n26 585
R6063 VSS.n26 VSS.n25 585
R6064 VSS.n2127 VSS.n2126 585
R6065 VSS.n2126 VSS.n2125 585
R6066 VSS.n437 VSS.n329 585
R6067 VSS.n2124 VSS.n329 585
R6068 VSS.n439 VSS.n332 585
R6069 VSS.n2123 VSS.n332 585
R6070 VSS.n1924 VSS.n1923 585
R6071 VSS.n1923 VSS.n1922 585
R6072 VSS.n450 VSS.n444 585
R6073 VSS.n1921 VSS.n444 585
R6074 VSS.n1919 VSS.n1918 585
R6075 VSS.n1920 VSS.n1919 585
R6076 VSS.n451 VSS.n449 585
R6077 VSS.n449 VSS.n448 585
R6078 VSS.n1914 VSS.n1913 585
R6079 VSS.n1913 VSS.n1912 585
R6080 VSS.n460 VSS.n454 585
R6081 VSS.n1911 VSS.n454 585
R6082 VSS.n1909 VSS.n1908 585
R6083 VSS.n1910 VSS.n1909 585
R6084 VSS.n462 VSS.n459 585
R6085 VSS.n459 VSS.n458 585
R6086 VSS.n1903 VSS.n1902 585
R6087 VSS.n1902 VSS.n1901 585
R6088 VSS.n472 VSS.n466 585
R6089 VSS.n1900 VSS.n466 585
R6090 VSS.n1898 VSS.n1897 585
R6091 VSS.n1899 VSS.n1898 585
R6092 VSS.n474 VSS.n471 585
R6093 VSS.n471 VSS.n470 585
R6094 VSS.n1892 VSS.n1891 585
R6095 VSS.n1891 VSS.n1890 585
R6096 VSS.n484 VSS.n478 585
R6097 VSS.n1889 VSS.n478 585
R6098 VSS.n1887 VSS.n1886 585
R6099 VSS.n1888 VSS.n1887 585
R6100 VSS.n486 VSS.n483 585
R6101 VSS.n483 VSS.n482 585
R6102 VSS.n1881 VSS.n1880 585
R6103 VSS.n495 VSS.n490 585
R6104 VSS.n1877 VSS.n1876 585
R6105 VSS.n1878 VSS.n1877 585
R6106 VSS.n497 VSS.n494 585
R6107 VSS.n1872 VSS.n500 585
R6108 VSS.n1871 VSS.n1870 585
R6109 VSS.n1868 VSS.n1867 585
R6110 VSS.n1866 VSS.n1865 585
R6111 VSS.n1866 VSS.n493 585
R6112 VSS.n10 VSS.n8 585
R6113 VSS.n171 VSS.n170 585
R6114 VSS.n174 VSS.n173 585
R6115 VSS.n176 VSS.n167 585
R6116 VSS.n178 VSS.n177 585
R6117 VSS.n164 VSS.n162 585
R6118 VSS.n184 VSS.n183 585
R6119 VSS.n186 VSS.n161 585
R6120 VSS.n188 VSS.n187 585
R6121 VSS.n156 VSS.n154 585
R6122 VSS.n194 VSS.n193 585
R6123 VSS.n196 VSS.n153 585
R6124 VSS.n198 VSS.n197 585
R6125 VSS.n148 VSS.n146 585
R6126 VSS.n204 VSS.n203 585
R6127 VSS.n206 VSS.n145 585
R6128 VSS.n208 VSS.n207 585
R6129 VSS.n132 VSS.n131 585
R6130 VSS.n214 VSS.n213 585
R6131 VSS.n217 VSS.n216 585
R6132 VSS.n130 VSS.n125 585
R6133 VSS.n221 VSS.n123 585
R6134 VSS.n223 VSS.n222 585
R6135 VSS.n225 VSS.n122 585
R6136 VSS.n227 VSS.n226 585
R6137 VSS.n117 VSS.n115 585
R6138 VSS.n233 VSS.n232 585
R6139 VSS.n235 VSS.n114 585
R6140 VSS.n237 VSS.n236 585
R6141 VSS.n98 VSS.n96 585
R6142 VSS.n243 VSS.n242 585
R6143 VSS.n245 VSS.n95 585
R6144 VSS.n247 VSS.n246 585
R6145 VSS.n90 VSS.n88 585
R6146 VSS.n253 VSS.n252 585
R6147 VSS.n255 VSS.n87 585
R6148 VSS.n257 VSS.n256 585
R6149 VSS.n83 VSS.n82 585
R6150 VSS.n263 VSS.n262 585
R6151 VSS.n265 VSS.n80 585
R6152 VSS.n267 VSS.n266 585
R6153 VSS.n78 VSS.n77 585
R6154 VSS.n273 VSS.n272 585
R6155 VSS.n276 VSS.n275 585
R6156 VSS.n76 VSS.n73 585
R6157 VSS.n60 VSS.n58 585
R6158 VSS.n283 VSS.n282 585
R6159 VSS.n285 VSS.n57 585
R6160 VSS.n287 VSS.n286 585
R6161 VSS.n52 VSS.n50 585
R6162 VSS.n293 VSS.n292 585
R6163 VSS.n295 VSS.n49 585
R6164 VSS.n297 VSS.n296 585
R6165 VSS.n45 VSS.n44 585
R6166 VSS.n303 VSS.n302 585
R6167 VSS.n306 VSS.n305 585
R6168 VSS.n43 VSS.n39 585
R6169 VSS.n310 VSS.n38 585
R6170 VSS.n312 VSS.n311 585
R6171 VSS.n315 VSS.n314 585
R6172 VSS.n36 VSS.n14 585
R6173 VSS.n14 VSS.n12 585
R6174 VSS.n2143 VSS.n14 286.637
R6175 VSS.n2145 VSS.n10 286.637
R6176 VSS.n938 VSS.n922 259.37
R6177 VSS.n953 VSS.n922 259.37
R6178 VSS.n1327 VSS.n654 256.663
R6179 VSS.n1330 VSS.n654 256.663
R6180 VSS.n1346 VSS.n654 256.663
R6181 VSS.n1525 VSS.n761 256.663
R6182 VSS.n1525 VSS.n760 256.663
R6183 VSS.n1525 VSS.n759 256.663
R6184 VSS.n1525 VSS.n758 256.663
R6185 VSS.n1194 VSS.n1193 256.663
R6186 VSS.n1162 VSS.n1161 256.663
R6187 VSS.n1686 VSS.n1685 256.663
R6188 VSS.n1685 VSS.n1617 256.663
R6189 VSS.n1685 VSS.n1618 256.663
R6190 VSS.n1879 VSS.n1878 256.663
R6191 VSS.n1878 VSS.n491 256.663
R6192 VSS.n1878 VSS.n492 256.663
R6193 VSS.n981 VSS.n980 256.483
R6194 VSS.n1126 VSS.n1125 256.483
R6195 VSS.n941 VSS.n922 244.279
R6196 VSS.n951 VSS.n922 244.279
R6197 VSS.n1932 VSS.n333 244.279
R6198 VSS.n1940 VSS.n333 244.279
R6199 VSS.n1942 VSS.n333 244.279
R6200 VSS.n1953 VSS.n333 244.279
R6201 VSS.n1955 VSS.n333 244.279
R6202 VSS.n1966 VSS.n333 244.279
R6203 VSS.n1968 VSS.n333 244.279
R6204 VSS.n1979 VSS.n333 244.279
R6205 VSS.n1981 VSS.n333 244.279
R6206 VSS.n1991 VSS.n333 244.279
R6207 VSS.n1993 VSS.n333 244.279
R6208 VSS.n2003 VSS.n333 244.279
R6209 VSS.n2005 VSS.n333 244.279
R6210 VSS.n2016 VSS.n333 244.279
R6211 VSS.n2018 VSS.n333 244.279
R6212 VSS.n2029 VSS.n333 244.279
R6213 VSS.n2031 VSS.n333 244.279
R6214 VSS.n2042 VSS.n333 244.279
R6215 VSS.n2044 VSS.n333 244.279
R6216 VSS.n2052 VSS.n333 244.279
R6217 VSS.n2054 VSS.n333 244.279
R6218 VSS.n2065 VSS.n333 244.279
R6219 VSS.n2067 VSS.n333 244.279
R6220 VSS.n2078 VSS.n333 244.279
R6221 VSS.n2080 VSS.n333 244.279
R6222 VSS.n2091 VSS.n333 244.279
R6223 VSS.n2093 VSS.n333 244.279
R6224 VSS.n2103 VSS.n333 244.279
R6225 VSS.n2105 VSS.n333 244.279
R6226 VSS.n2113 VSS.n333 244.279
R6227 VSS.n169 VSS.n12 244.279
R6228 VSS.n175 VSS.n12 244.279
R6229 VSS.n168 VSS.n12 244.279
R6230 VSS.n185 VSS.n12 244.279
R6231 VSS.n160 VSS.n12 244.279
R6232 VSS.n195 VSS.n12 244.279
R6233 VSS.n152 VSS.n12 244.279
R6234 VSS.n205 VSS.n12 244.279
R6235 VSS.n144 VSS.n12 244.279
R6236 VSS.n215 VSS.n12 244.279
R6237 VSS.n129 VSS.n12 244.279
R6238 VSS.n224 VSS.n12 244.279
R6239 VSS.n121 VSS.n12 244.279
R6240 VSS.n234 VSS.n12 244.279
R6241 VSS.n113 VSS.n12 244.279
R6242 VSS.n244 VSS.n12 244.279
R6243 VSS.n94 VSS.n12 244.279
R6244 VSS.n254 VSS.n12 244.279
R6245 VSS.n86 VSS.n12 244.279
R6246 VSS.n264 VSS.n12 244.279
R6247 VSS.n81 VSS.n12 244.279
R6248 VSS.n274 VSS.n12 244.279
R6249 VSS.n75 VSS.n12 244.279
R6250 VSS.n284 VSS.n12 244.279
R6251 VSS.n56 VSS.n12 244.279
R6252 VSS.n294 VSS.n12 244.279
R6253 VSS.n48 VSS.n12 244.279
R6254 VSS.n304 VSS.n12 244.279
R6255 VSS.n42 VSS.n12 244.279
R6256 VSS.n313 VSS.n12 244.279
R6257 VSS.n1859 VSS.n502 230.966
R6258 VSS.n1859 VSS.n506 230.966
R6259 VSS.n1855 VSS.n506 230.966
R6260 VSS.n1855 VSS.n509 230.966
R6261 VSS.n1848 VSS.n509 230.966
R6262 VSS.n1848 VSS.n516 230.966
R6263 VSS.n1844 VSS.n516 230.966
R6264 VSS.n1844 VSS.n518 230.966
R6265 VSS.n1837 VSS.n518 230.966
R6266 VSS.n1837 VSS.n525 230.966
R6267 VSS.n1833 VSS.n525 230.966
R6268 VSS.n1833 VSS.n527 230.966
R6269 VSS.n535 VSS.n527 230.966
R6270 VSS.n1826 VSS.n535 230.966
R6271 VSS.n1826 VSS.n536 230.966
R6272 VSS.n1822 VSS.n536 230.966
R6273 VSS.n1822 VSS.n539 230.966
R6274 VSS.n1815 VSS.n539 230.966
R6275 VSS.n1815 VSS.n546 230.966
R6276 VSS.n1811 VSS.n546 230.966
R6277 VSS.n1811 VSS.n548 230.966
R6278 VSS.n1804 VSS.n548 230.966
R6279 VSS.n1804 VSS.n555 230.966
R6280 VSS.n1800 VSS.n555 230.966
R6281 VSS.n1800 VSS.n557 230.966
R6282 VSS.n1793 VSS.n557 230.966
R6283 VSS.n1793 VSS.n564 230.966
R6284 VSS.n1789 VSS.n564 230.966
R6285 VSS.n1789 VSS.n567 230.966
R6286 VSS.n1782 VSS.n567 230.966
R6287 VSS.n1782 VSS.n574 230.966
R6288 VSS.n1778 VSS.n574 230.966
R6289 VSS.n1778 VSS.n576 230.966
R6290 VSS.n1771 VSS.n576 230.966
R6291 VSS.n1771 VSS.n581 230.966
R6292 VSS.n1767 VSS.n581 230.966
R6293 VSS.n1767 VSS.n583 230.966
R6294 VSS.n1760 VSS.n583 230.966
R6295 VSS.n1760 VSS.n590 230.966
R6296 VSS.n1756 VSS.n590 230.966
R6297 VSS.n1756 VSS.n592 230.966
R6298 VSS.n1749 VSS.n592 230.966
R6299 VSS.n1749 VSS.n599 230.966
R6300 VSS.n1745 VSS.n599 230.966
R6301 VSS.n1745 VSS.n601 230.966
R6302 VSS.n1738 VSS.n601 230.966
R6303 VSS.n1738 VSS.n608 230.966
R6304 VSS.n1734 VSS.n608 230.966
R6305 VSS.n1734 VSS.n610 230.966
R6306 VSS.n617 VSS.n610 230.966
R6307 VSS.n1726 VSS.n617 230.966
R6308 VSS.n1726 VSS.n618 230.966
R6309 VSS.n1722 VSS.n618 230.966
R6310 VSS.n1722 VSS.n621 230.966
R6311 VSS.n1715 VSS.n621 230.966
R6312 VSS.n1715 VSS.n628 230.966
R6313 VSS.n1711 VSS.n628 230.966
R6314 VSS.n1711 VSS.n630 230.966
R6315 VSS.n1704 VSS.n630 230.966
R6316 VSS.n1704 VSS.n637 230.966
R6317 VSS.n1700 VSS.n637 230.966
R6318 VSS.n660 VSS.n659 230.966
R6319 VSS.n661 VSS.n660 230.966
R6320 VSS.n1298 VSS.n661 230.966
R6321 VSS.n1298 VSS.n670 230.966
R6322 VSS.n671 VSS.n670 230.966
R6323 VSS.n672 VSS.n671 230.966
R6324 VSS.n1369 VSS.n672 230.966
R6325 VSS.n1369 VSS.n683 230.966
R6326 VSS.n684 VSS.n683 230.966
R6327 VSS.n685 VSS.n684 230.966
R6328 VSS.n1380 VSS.n685 230.966
R6329 VSS.n1382 VSS.n1380 230.966
R6330 VSS.n1382 VSS.n696 230.966
R6331 VSS.n697 VSS.n696 230.966
R6332 VSS.n698 VSS.n697 230.966
R6333 VSS.n1392 VSS.n698 230.966
R6334 VSS.n1392 VSS.n1287 230.966
R6335 VSS.n1401 VSS.n1287 230.966
R6336 VSS.n1401 VSS.n1275 230.966
R6337 VSS.n1414 VSS.n1275 230.966
R6338 VSS.n1414 VSS.n1270 230.966
R6339 VSS.n1423 VSS.n1270 230.966
R6340 VSS.n1423 VSS.n1246 230.966
R6341 VSS.n1436 VSS.n1246 230.966
R6342 VSS.n1436 VSS.n1242 230.966
R6343 VSS.n1444 VSS.n1242 230.966
R6344 VSS.n1444 VSS.n1234 230.966
R6345 VSS.n1456 VSS.n1234 230.966
R6346 VSS.n1456 VSS.n1228 230.966
R6347 VSS.n1464 VSS.n1228 230.966
R6348 VSS.n1464 VSS.n1219 230.966
R6349 VSS.n1476 VSS.n1219 230.966
R6350 VSS.n1476 VSS.n1220 230.966
R6351 VSS.n1220 VSS.n744 230.966
R6352 VSS.n745 VSS.n744 230.966
R6353 VSS.n746 VSS.n745 230.966
R6354 VSS.n1489 VSS.n746 230.966
R6355 VSS.n1489 VSS.n756 230.966
R6356 VSS.n757 VSS.n756 230.966
R6357 VSS.n1614 VSS.n657 230.966
R6358 VSS.n1610 VSS.n657 230.966
R6359 VSS.n1610 VSS.n663 230.966
R6360 VSS.n1603 VSS.n663 230.966
R6361 VSS.n1603 VSS.n669 230.966
R6362 VSS.n1599 VSS.n669 230.966
R6363 VSS.n1599 VSS.n674 230.966
R6364 VSS.n1592 VSS.n674 230.966
R6365 VSS.n1592 VSS.n682 230.966
R6366 VSS.n1588 VSS.n682 230.966
R6367 VSS.n1588 VSS.n687 230.966
R6368 VSS.n694 VSS.n687 230.966
R6369 VSS.n1580 VSS.n694 230.966
R6370 VSS.n1580 VSS.n695 230.966
R6371 VSS.n1576 VSS.n695 230.966
R6372 VSS.n1576 VSS.n700 230.966
R6373 VSS.n1285 VSS.n700 230.966
R6374 VSS.n1403 VSS.n1285 230.966
R6375 VSS.n1403 VSS.n1278 230.966
R6376 VSS.n1412 VSS.n1278 230.966
R6377 VSS.n1412 VSS.n1269 230.966
R6378 VSS.n1425 VSS.n1269 230.966
R6379 VSS.n1425 VSS.n1248 230.966
R6380 VSS.n1434 VSS.n1248 230.966
R6381 VSS.n1434 VSS.n1240 230.966
R6382 VSS.n1446 VSS.n1240 230.966
R6383 VSS.n1446 VSS.n1236 230.966
R6384 VSS.n1454 VSS.n1236 230.966
R6385 VSS.n1454 VSS.n1226 230.966
R6386 VSS.n1466 VSS.n1226 230.966
R6387 VSS.n1466 VSS.n1222 230.966
R6388 VSS.n1474 VSS.n1222 230.966
R6389 VSS.n1474 VSS.n741 230.966
R6390 VSS.n1539 VSS.n741 230.966
R6391 VSS.n1539 VSS.n742 230.966
R6392 VSS.n1535 VSS.n742 230.966
R6393 VSS.n1535 VSS.n748 230.966
R6394 VSS.n1528 VSS.n748 230.966
R6395 VSS.n1528 VSS.n755 230.966
R6396 VSS.n940 VSS.n939 230.966
R6397 VSS.n942 VSS.n940 230.966
R6398 VSS.n950 VSS.n928 230.966
R6399 VSS.n954 VSS.n952 230.966
R6400 VSS.n1184 VSS.n1183 230.966
R6401 VSS.n1183 VSS.n771 230.966
R6402 VSS.n1179 VSS.n771 230.966
R6403 VSS.n1179 VSS.n774 230.966
R6404 VSS.n1175 VSS.n774 230.966
R6405 VSS.n1175 VSS.n783 230.966
R6406 VSS.n1171 VSS.n783 230.966
R6407 VSS.n1171 VSS.n785 230.966
R6408 VSS.n314 VSS.n14 230.966
R6409 VSS.n312 VSS.n38 230.966
R6410 VSS.n305 VSS.n43 230.966
R6411 VSS.n303 VSS.n44 230.966
R6412 VSS.n296 VSS.n295 230.966
R6413 VSS.n293 VSS.n50 230.966
R6414 VSS.n286 VSS.n285 230.966
R6415 VSS.n283 VSS.n58 230.966
R6416 VSS.n275 VSS.n76 230.966
R6417 VSS.n273 VSS.n77 230.966
R6418 VSS.n266 VSS.n265 230.966
R6419 VSS.n263 VSS.n82 230.966
R6420 VSS.n256 VSS.n255 230.966
R6421 VSS.n253 VSS.n88 230.966
R6422 VSS.n246 VSS.n245 230.966
R6423 VSS.n243 VSS.n96 230.966
R6424 VSS.n236 VSS.n235 230.966
R6425 VSS.n233 VSS.n115 230.966
R6426 VSS.n226 VSS.n225 230.966
R6427 VSS.n223 VSS.n123 230.966
R6428 VSS.n216 VSS.n130 230.966
R6429 VSS.n214 VSS.n131 230.966
R6430 VSS.n207 VSS.n206 230.966
R6431 VSS.n204 VSS.n146 230.966
R6432 VSS.n197 VSS.n196 230.966
R6433 VSS.n194 VSS.n154 230.966
R6434 VSS.n187 VSS.n186 230.966
R6435 VSS.n184 VSS.n162 230.966
R6436 VSS.n177 VSS.n176 230.966
R6437 VSS.n174 VSS.n170 230.966
R6438 VSS.n1933 VSS.n430 230.966
R6439 VSS.n1939 VSS.n430 230.966
R6440 VSS.n1943 VSS.n1941 230.966
R6441 VSS.n1952 VSS.n425 230.966
R6442 VSS.n1956 VSS.n1954 230.966
R6443 VSS.n1965 VSS.n420 230.966
R6444 VSS.n1969 VSS.n1967 230.966
R6445 VSS.n1978 VSS.n415 230.966
R6446 VSS.n1982 VSS.n1980 230.966
R6447 VSS.n1990 VSS.n410 230.966
R6448 VSS.n1994 VSS.n1992 230.966
R6449 VSS.n2002 VSS.n406 230.966
R6450 VSS.n2006 VSS.n2004 230.966
R6451 VSS.n2015 VSS.n401 230.966
R6452 VSS.n2019 VSS.n2017 230.966
R6453 VSS.n2028 VSS.n396 230.966
R6454 VSS.n2032 VSS.n2030 230.966
R6455 VSS.n2041 VSS.n391 230.966
R6456 VSS.n2045 VSS.n2043 230.966
R6457 VSS.n2051 VSS.n386 230.966
R6458 VSS.n2055 VSS.n2053 230.966
R6459 VSS.n2064 VSS.n381 230.966
R6460 VSS.n2068 VSS.n2066 230.966
R6461 VSS.n2077 VSS.n376 230.966
R6462 VSS.n2081 VSS.n2079 230.966
R6463 VSS.n2090 VSS.n371 230.966
R6464 VSS.n2094 VSS.n2092 230.966
R6465 VSS.n2102 VSS.n366 230.966
R6466 VSS.n2106 VSS.n2104 230.966
R6467 VSS.n2112 VSS.n362 230.966
R6468 VSS.n1161 VSS.n1160 230.918
R6469 VSS.n963 VSS.n923 230.635
R6470 VSS.n965 VSS.n921 230.635
R6471 VSS.n1923 VSS.n434 230.635
R6472 VSS.n1867 VSS.n1866 230.635
R6473 VSS.n445 VSS.n334 230.635
R6474 VSS.n1687 VSS.n639 230.635
R6475 VSS.n1615 VSS.n656 225.829
R6476 VSS.n1348 VSS.n653 225.829
R6477 VSS.n1499 VSS.n762 225.829
R6478 VSS.n1931 VSS.n434 224.173
R6479 VSS.n2114 VSS.n334 224.173
R6480 VSS.n1163 VSS.n785 218.706
R6481 VSS.n1184 VSS.n764 218.706
R6482 VSS.n1195 VSS.n755 210.587
R6483 VSS.n984 VSS.n981 185
R6484 VSS.n887 VSS.n886 185
R6485 VSS.n1014 VSS.n1013 185
R6486 VSS.n1015 VSS.n885 185
R6487 VSS.n1017 VSS.n1016 185
R6488 VSS.n863 VSS.n862 185
R6489 VSS.n1047 VSS.n1046 185
R6490 VSS.n1048 VSS.n861 185
R6491 VSS.n1050 VSS.n1049 185
R6492 VSS.n842 VSS.n841 185
R6493 VSS.n1084 VSS.n1083 185
R6494 VSS.n1085 VSS.n840 185
R6495 VSS.n1089 VSS.n1086 185
R6496 VSS.n1088 VSS.n1087 185
R6497 VSS.n817 VSS.n816 185
R6498 VSS.n1123 VSS.n1122 185
R6499 VSS.n1124 VSS.n815 185
R6500 VSS.n1128 VSS.n1125 185
R6501 VSS.n964 VSS.n922 164.231
R6502 VSS.n1329 VSS.n1328 163.367
R6503 VSS.n1331 VSS.n1329 163.367
R6504 VSS.n1345 VSS.n1305 163.367
R6505 VSS.n1348 VSS.n1347 163.367
R6506 VSS.n1515 VSS.n1514 163.367
R6507 VSS.n1208 VSS.n1207 163.367
R6508 VSS.n1503 VSS.n1502 163.367
R6509 VSS.n963 VSS.n915 163.367
R6510 VSS.n975 VSS.n915 163.367
R6511 VSS.n975 VSS.n905 163.367
R6512 VSS.n997 VSS.n905 163.367
R6513 VSS.n997 VSS.n895 163.367
R6514 VSS.n1008 VSS.n895 163.367
R6515 VSS.n1008 VSS.n880 163.367
R6516 VSS.n1028 VSS.n880 163.367
R6517 VSS.n1028 VSS.n870 163.367
R6518 VSS.n1041 VSS.n870 163.367
R6519 VSS.n1041 VSS.n856 163.367
R6520 VSS.n1065 VSS.n856 163.367
R6521 VSS.n1065 VSS.n848 163.367
R6522 VSS.n1078 VSS.n848 163.367
R6523 VSS.n1078 VSS.n832 163.367
R6524 VSS.n1103 VSS.n832 163.367
R6525 VSS.n1103 VSS.n823 163.367
R6526 VSS.n1116 VSS.n823 163.367
R6527 VSS.n1116 VSS.n812 163.367
R6528 VSS.n1134 VSS.n812 163.367
R6529 VSS.n1134 VSS.n803 163.367
R6530 VSS.n1148 VSS.n803 163.367
R6531 VSS.n1148 VSS.n795 163.367
R6532 VSS.n1159 VSS.n795 163.367
R6533 VSS.n1159 VSS.n793 163.367
R6534 VSS.n965 VSS.n917 163.367
R6535 VSS.n973 VSS.n917 163.367
R6536 VSS.n973 VSS.n903 163.367
R6537 VSS.n999 VSS.n903 163.367
R6538 VSS.n999 VSS.n897 163.367
R6539 VSS.n1006 VSS.n897 163.367
R6540 VSS.n1006 VSS.n878 163.367
R6541 VSS.n1030 VSS.n878 163.367
R6542 VSS.n1030 VSS.n873 163.367
R6543 VSS.n1039 VSS.n873 163.367
R6544 VSS.n1039 VSS.n855 163.367
R6545 VSS.n1067 VSS.n855 163.367
R6546 VSS.n1067 VSS.n850 163.367
R6547 VSS.n1076 VSS.n850 163.367
R6548 VSS.n1076 VSS.n830 163.367
R6549 VSS.n1105 VSS.n830 163.367
R6550 VSS.n1105 VSS.n825 163.367
R6551 VSS.n1114 VSS.n825 163.367
R6552 VSS.n1114 VSS.n810 163.367
R6553 VSS.n1136 VSS.n810 163.367
R6554 VSS.n1136 VSS.n805 163.367
R6555 VSS.n1146 VSS.n805 163.367
R6556 VSS.n1146 VSS.n806 163.367
R6557 VSS.n806 VSS.n765 163.367
R6558 VSS.n1192 VSS.n765 163.367
R6559 VSS.n2143 VSS.n15 163.367
R6560 VSS.n2136 VSS.n15 163.367
R6561 VSS.n2136 VSS.n21 163.367
R6562 VSS.n2132 VSS.n21 163.367
R6563 VSS.n2132 VSS.n26 163.367
R6564 VSS.n2126 VSS.n26 163.367
R6565 VSS.n2126 VSS.n329 163.367
R6566 VSS.n332 VSS.n329 163.367
R6567 VSS.n1923 VSS.n444 163.367
R6568 VSS.n1919 VSS.n444 163.367
R6569 VSS.n1919 VSS.n449 163.367
R6570 VSS.n1913 VSS.n449 163.367
R6571 VSS.n1913 VSS.n454 163.367
R6572 VSS.n1909 VSS.n454 163.367
R6573 VSS.n1909 VSS.n459 163.367
R6574 VSS.n1902 VSS.n459 163.367
R6575 VSS.n1902 VSS.n466 163.367
R6576 VSS.n1898 VSS.n466 163.367
R6577 VSS.n1898 VSS.n471 163.367
R6578 VSS.n1891 VSS.n471 163.367
R6579 VSS.n1891 VSS.n478 163.367
R6580 VSS.n1887 VSS.n478 163.367
R6581 VSS.n1887 VSS.n483 163.367
R6582 VSS.n1880 VSS.n483 163.367
R6583 VSS.n1877 VSS.n490 163.367
R6584 VSS.n1877 VSS.n494 163.367
R6585 VSS.n1870 VSS.n500 163.367
R6586 VSS.n2145 VSS.n11 163.367
R6587 VSS.n22 VSS.n11 163.367
R6588 VSS.n23 VSS.n22 163.367
R6589 VSS.n24 VSS.n23 163.367
R6590 VSS.n351 VSS.n24 163.367
R6591 VSS.n351 VSS.n330 163.367
R6592 VSS.n331 VSS.n330 163.367
R6593 VSS.n2122 VSS.n331 163.367
R6594 VSS.n446 VSS.n445 163.367
R6595 VSS.n447 VSS.n446 163.367
R6596 VSS.n1630 VSS.n447 163.367
R6597 VSS.n1630 VSS.n455 163.367
R6598 VSS.n456 VSS.n455 163.367
R6599 VSS.n457 VSS.n456 163.367
R6600 VSS.n1648 VSS.n457 163.367
R6601 VSS.n1648 VSS.n467 163.367
R6602 VSS.n468 VSS.n467 163.367
R6603 VSS.n469 VSS.n468 163.367
R6604 VSS.n1658 VSS.n469 163.367
R6605 VSS.n1658 VSS.n479 163.367
R6606 VSS.n480 VSS.n479 163.367
R6607 VSS.n481 VSS.n480 163.367
R6608 VSS.n1619 VSS.n481 163.367
R6609 VSS.n1684 VSS.n1619 163.367
R6610 VSS.n1684 VSS.n1620 163.367
R6611 VSS.n1677 VSS.n1676 163.367
R6612 VSS.n1673 VSS.n652 163.367
R6613 VSS.n1199 VSS.n1195 156.16
R6614 VSS.n981 VSS.n886 144
R6615 VSS.n1014 VSS.n886 144
R6616 VSS.n1015 VSS.n1014 144
R6617 VSS.n1016 VSS.n1015 144
R6618 VSS.n1016 VSS.n862 144
R6619 VSS.n1047 VSS.n862 144
R6620 VSS.n1048 VSS.n1047 144
R6621 VSS.n1049 VSS.n1048 144
R6622 VSS.n1084 VSS.n841 144
R6623 VSS.n1085 VSS.n1084 144
R6624 VSS.n1086 VSS.n1085 144
R6625 VSS.n1087 VSS.n1086 144
R6626 VSS.n1087 VSS.n816 144
R6627 VSS.n1123 VSS.n816 144
R6628 VSS.n1124 VSS.n1123 144
R6629 VSS.n1125 VSS.n1124 144
R6630 VSS.n321 VSS.t3 122.064
R6631 VSS.n1 VSS.t26 122.064
R6632 VSS.n964 VSS.n916 116.331
R6633 VSS.n974 VSS.n916 116.331
R6634 VSS.n974 VSS.n904 116.331
R6635 VSS.n998 VSS.n904 116.331
R6636 VSS.n998 VSS.n896 116.331
R6637 VSS.n1007 VSS.n896 116.331
R6638 VSS.n1007 VSS.n879 116.331
R6639 VSS.n1029 VSS.n879 116.331
R6640 VSS.n1029 VSS.n871 116.331
R6641 VSS.n1040 VSS.n871 116.331
R6642 VSS.n1040 VSS.n872 116.331
R6643 VSS.n1066 VSS.n849 116.331
R6644 VSS.n1077 VSS.n849 116.331
R6645 VSS.n1077 VSS.n831 116.331
R6646 VSS.n1104 VSS.n831 116.331
R6647 VSS.n1104 VSS.n824 116.331
R6648 VSS.n1115 VSS.n824 116.331
R6649 VSS.n1115 VSS.n811 116.331
R6650 VSS.n1135 VSS.n811 116.331
R6651 VSS.n1135 VSS.n804 116.331
R6652 VSS.n1147 VSS.n804 116.331
R6653 VSS.n1147 VSS.n794 116.331
R6654 VSS.n1160 VSS.n794 116.331
R6655 VSS.n1866 VSS.n502 108.691
R6656 VSS.n1700 VSS.n639 108.691
R6657 VSS.n942 VSS.n941 96.4451
R6658 VSS.n951 VSS.n950 96.4451
R6659 VSS.n941 VSS.n928 96.4451
R6660 VSS.n952 VSS.n951 96.4451
R6661 VSS.n313 VSS.n312 96.4451
R6662 VSS.n43 VSS.n42 96.4451
R6663 VSS.n304 VSS.n303 96.4451
R6664 VSS.n296 VSS.n48 96.4451
R6665 VSS.n294 VSS.n293 96.4451
R6666 VSS.n286 VSS.n56 96.4451
R6667 VSS.n284 VSS.n283 96.4451
R6668 VSS.n76 VSS.n75 96.4451
R6669 VSS.n274 VSS.n273 96.4451
R6670 VSS.n266 VSS.n81 96.4451
R6671 VSS.n264 VSS.n263 96.4451
R6672 VSS.n256 VSS.n86 96.4451
R6673 VSS.n254 VSS.n253 96.4451
R6674 VSS.n246 VSS.n94 96.4451
R6675 VSS.n244 VSS.n243 96.4451
R6676 VSS.n236 VSS.n113 96.4451
R6677 VSS.n234 VSS.n233 96.4451
R6678 VSS.n226 VSS.n121 96.4451
R6679 VSS.n224 VSS.n223 96.4451
R6680 VSS.n130 VSS.n129 96.4451
R6681 VSS.n215 VSS.n214 96.4451
R6682 VSS.n207 VSS.n144 96.4451
R6683 VSS.n205 VSS.n204 96.4451
R6684 VSS.n197 VSS.n152 96.4451
R6685 VSS.n195 VSS.n194 96.4451
R6686 VSS.n187 VSS.n160 96.4451
R6687 VSS.n185 VSS.n184 96.4451
R6688 VSS.n177 VSS.n168 96.4451
R6689 VSS.n175 VSS.n174 96.4451
R6690 VSS.n169 VSS.n10 96.4451
R6691 VSS.n1932 VSS.n1931 96.4451
R6692 VSS.n1940 VSS.n1939 96.4451
R6693 VSS.n1943 VSS.n1942 96.4451
R6694 VSS.n1953 VSS.n1952 96.4451
R6695 VSS.n1956 VSS.n1955 96.4451
R6696 VSS.n1966 VSS.n1965 96.4451
R6697 VSS.n1969 VSS.n1968 96.4451
R6698 VSS.n1979 VSS.n1978 96.4451
R6699 VSS.n1982 VSS.n1981 96.4451
R6700 VSS.n1991 VSS.n1990 96.4451
R6701 VSS.n1994 VSS.n1993 96.4451
R6702 VSS.n2003 VSS.n2002 96.4451
R6703 VSS.n2006 VSS.n2005 96.4451
R6704 VSS.n2016 VSS.n2015 96.4451
R6705 VSS.n2019 VSS.n2018 96.4451
R6706 VSS.n2029 VSS.n2028 96.4451
R6707 VSS.n2032 VSS.n2031 96.4451
R6708 VSS.n2042 VSS.n2041 96.4451
R6709 VSS.n2045 VSS.n2044 96.4451
R6710 VSS.n2052 VSS.n2051 96.4451
R6711 VSS.n2055 VSS.n2054 96.4451
R6712 VSS.n2065 VSS.n2064 96.4451
R6713 VSS.n2068 VSS.n2067 96.4451
R6714 VSS.n2078 VSS.n2077 96.4451
R6715 VSS.n2081 VSS.n2080 96.4451
R6716 VSS.n2091 VSS.n2090 96.4451
R6717 VSS.n2094 VSS.n2093 96.4451
R6718 VSS.n2103 VSS.n2102 96.4451
R6719 VSS.n2106 VSS.n2105 96.4451
R6720 VSS.n2113 VSS.n2112 96.4451
R6721 VSS.n1933 VSS.n1932 96.4451
R6722 VSS.n1941 VSS.n1940 96.4451
R6723 VSS.n1942 VSS.n425 96.4451
R6724 VSS.n1954 VSS.n1953 96.4451
R6725 VSS.n1955 VSS.n420 96.4451
R6726 VSS.n1967 VSS.n1966 96.4451
R6727 VSS.n1968 VSS.n415 96.4451
R6728 VSS.n1980 VSS.n1979 96.4451
R6729 VSS.n1981 VSS.n410 96.4451
R6730 VSS.n1992 VSS.n1991 96.4451
R6731 VSS.n1993 VSS.n406 96.4451
R6732 VSS.n2004 VSS.n2003 96.4451
R6733 VSS.n2005 VSS.n401 96.4451
R6734 VSS.n2017 VSS.n2016 96.4451
R6735 VSS.n2018 VSS.n396 96.4451
R6736 VSS.n2030 VSS.n2029 96.4451
R6737 VSS.n2031 VSS.n391 96.4451
R6738 VSS.n2043 VSS.n2042 96.4451
R6739 VSS.n2044 VSS.n386 96.4451
R6740 VSS.n2053 VSS.n2052 96.4451
R6741 VSS.n2054 VSS.n381 96.4451
R6742 VSS.n2066 VSS.n2065 96.4451
R6743 VSS.n2067 VSS.n376 96.4451
R6744 VSS.n2079 VSS.n2078 96.4451
R6745 VSS.n2080 VSS.n371 96.4451
R6746 VSS.n2092 VSS.n2091 96.4451
R6747 VSS.n2093 VSS.n366 96.4451
R6748 VSS.n2104 VSS.n2103 96.4451
R6749 VSS.n2105 VSS.n362 96.4451
R6750 VSS.n2114 VSS.n2113 96.4451
R6751 VSS.n170 VSS.n169 96.4451
R6752 VSS.n176 VSS.n175 96.4451
R6753 VSS.n168 VSS.n162 96.4451
R6754 VSS.n186 VSS.n185 96.4451
R6755 VSS.n160 VSS.n154 96.4451
R6756 VSS.n196 VSS.n195 96.4451
R6757 VSS.n152 VSS.n146 96.4451
R6758 VSS.n206 VSS.n205 96.4451
R6759 VSS.n144 VSS.n131 96.4451
R6760 VSS.n216 VSS.n215 96.4451
R6761 VSS.n129 VSS.n123 96.4451
R6762 VSS.n225 VSS.n224 96.4451
R6763 VSS.n121 VSS.n115 96.4451
R6764 VSS.n235 VSS.n234 96.4451
R6765 VSS.n113 VSS.n96 96.4451
R6766 VSS.n245 VSS.n244 96.4451
R6767 VSS.n94 VSS.n88 96.4451
R6768 VSS.n255 VSS.n254 96.4451
R6769 VSS.n86 VSS.n82 96.4451
R6770 VSS.n265 VSS.n264 96.4451
R6771 VSS.n81 VSS.n77 96.4451
R6772 VSS.n275 VSS.n274 96.4451
R6773 VSS.n75 VSS.n58 96.4451
R6774 VSS.n285 VSS.n284 96.4451
R6775 VSS.n56 VSS.n50 96.4451
R6776 VSS.n295 VSS.n294 96.4451
R6777 VSS.n48 VSS.n44 96.4451
R6778 VSS.n305 VSS.n304 96.4451
R6779 VSS.n42 VSS.n38 96.4451
R6780 VSS.n314 VSS.n313 96.4451
R6781 VSS.n136 VSS.n135 86.1871
R6782 VSS.n1265 VSS.n1264 86.1871
R6783 VSS.n1264 VSS.n1263 86.1871
R6784 VSS.n1570 VSS.n1569 86.1871
R6785 VSS.n1569 VSS.n1568 86.1871
R6786 VSS.n721 VSS.n720 86.1871
R6787 VSS.n722 VSS.n721 86.1871
R6788 VSS.n1549 VSS.n1548 86.1871
R6789 VSS.n1550 VSS.n1549 86.1871
R6790 VSS.n66 VSS.n65 86.1871
R6791 VSS.n104 VSS.n103 86.1871
R6792 VSS.n1922 VSS.n333 81.2938
R6793 VSS.n872 VSS.t27 80.4049
R6794 VSS.n1524 VSS.n1194 72.8222
R6795 VSS.n1049 VSS.t28 72.0005
R6796 VSS.t28 VSS.n841 72.0005
R6797 VSS.n1327 VSS.n656 71.676
R6798 VSS.n1331 VSS.n1330 71.676
R6799 VSS.n1346 VSS.n1345 71.676
R6800 VSS.n1515 VSS.n758 71.676
R6801 VSS.n1207 VSS.n759 71.676
R6802 VSS.n1502 VSS.n760 71.676
R6803 VSS.n1499 VSS.n761 71.676
R6804 VSS.n1163 VSS.n1162 71.676
R6805 VSS.n1193 VSS.n1192 71.676
R6806 VSS.n1328 VSS.n1327 71.676
R6807 VSS.n1330 VSS.n1305 71.676
R6808 VSS.n1347 VSS.n1346 71.676
R6809 VSS.n1503 VSS.n761 71.676
R6810 VSS.n1208 VSS.n760 71.676
R6811 VSS.n1514 VSS.n759 71.676
R6812 VSS.n1199 VSS.n758 71.676
R6813 VSS.n1193 VSS.n764 71.676
R6814 VSS.n1162 VSS.n793 71.676
R6815 VSS.n1880 VSS.n1879 71.676
R6816 VSS.n494 VSS.n491 71.676
R6817 VSS.n1870 VSS.n492 71.676
R6818 VSS.n1677 VSS.n1618 71.676
R6819 VSS.n1673 VSS.n1617 71.676
R6820 VSS.n1687 VSS.n1686 71.676
R6821 VSS.n1686 VSS.n652 71.676
R6822 VSS.n1676 VSS.n1617 71.676
R6823 VSS.n1620 VSS.n1618 71.676
R6824 VSS.n1879 VSS.n490 71.676
R6825 VSS.n500 VSS.n491 71.676
R6826 VSS.n1867 VSS.n492 71.676
R6827 VSS.n659 VSS.n653 71.3281
R6828 VSS.n762 VSS.n757 71.3281
R6829 VSS.n1615 VSS.n1614 71.3281
R6830 VSS.n938 VSS.n921 66.2615
R6831 VSS.n954 VSS.n953 66.2615
R6832 VSS.n939 VSS.n938 66.2615
R6833 VSS.n953 VSS.n923 66.2615
R6834 VSS.n434 VSS.n332 62.4639
R6835 VSS.n2122 VSS.n334 62.4639
R6836 VSS.n1685 VSS.n1616 61.3992
R6837 VSS.n2144 VSS.n13 57.5833
R6838 VSS.n2135 VSS.n13 57.5833
R6839 VSS.n2135 VSS.n2134 57.5833
R6840 VSS.n2133 VSS.n25 57.5833
R6841 VSS.n2125 VSS.n25 57.5833
R6842 VSS.n2125 VSS.n2124 57.5833
R6843 VSS.n2124 VSS.n2123 57.5833
R6844 VSS.n1922 VSS.n1921 57.5833
R6845 VSS.n1920 VSS.n448 57.5833
R6846 VSS.n1912 VSS.n448 57.5833
R6847 VSS.n1912 VSS.n1911 57.5833
R6848 VSS.n1910 VSS.n458 57.5833
R6849 VSS.n1901 VSS.n458 57.5833
R6850 VSS.n1900 VSS.n1899 57.5833
R6851 VSS.n1899 VSS.n470 57.5833
R6852 VSS.n1890 VSS.n470 57.5833
R6853 VSS.n1889 VSS.n1888 57.5833
R6854 VSS.n1888 VSS.n482 57.5833
R6855 VSS.t14 VSS.n1910 56.7365
R6856 VSS.n1901 VSS.t8 43.1876
R6857 VSS.t23 VSS.n1920 38.1067
R6858 VSS.n1066 VSS.t27 35.9259
R6859 VSS.n2134 VSS.t0 33.0259
R6860 VSS.n135 VSS.t15 30.0005
R6861 VSS.n135 VSS.t29 30.0005
R6862 VSS.n65 VSS.t19 30.0005
R6863 VSS.n65 VSS.t22 30.0005
R6864 VSS.n103 VSS.t11 30.0005
R6865 VSS.n103 VSS.t1 30.0005
R6866 VSS.t18 VSS.n1889 29.6387
R6867 VSS.n1890 VSS.t18 27.9451
R6868 VSS.n1262 VSS.n1252 27.1064
R6869 VSS.n1567 VSS.n706 27.1064
R6870 VSS.n714 VSS.n713 27.1064
R6871 VSS.n736 VSS.n735 27.1064
R6872 VSS.n985 VSS.n984 27.1064
R6873 VSS.n984 VSS.n887 27.1064
R6874 VSS.n1013 VSS.n887 27.1064
R6875 VSS.n1013 VSS.n885 27.1064
R6876 VSS.n1017 VSS.n885 27.1064
R6877 VSS.n1017 VSS.n863 27.1064
R6878 VSS.n1046 VSS.n863 27.1064
R6879 VSS.n1046 VSS.n861 27.1064
R6880 VSS.n1050 VSS.n861 27.1064
R6881 VSS.n1050 VSS.n842 27.1064
R6882 VSS.n1083 VSS.n842 27.1064
R6883 VSS.n1083 VSS.n840 27.1064
R6884 VSS.n1089 VSS.n840 27.1064
R6885 VSS.n1089 VSS.n1088 27.1064
R6886 VSS.n1088 VSS.n817 27.1064
R6887 VSS.n1122 VSS.n817 27.1064
R6888 VSS.n1122 VSS.n815 27.1064
R6889 VSS.n1128 VSS.n815 27.1064
R6890 VSS.n1128 VSS.n1127 27.1064
R6891 VSS.n980 VSS.n979 25.7818
R6892 VSS.n1126 VSS.n798 25.7818
R6893 VSS.t0 VSS.n2133 24.5579
R6894 VSS.n507 VSS.n493 24.2744
R6895 VSS.n1858 VSS.n507 24.2744
R6896 VSS.n1858 VSS.n1857 24.2744
R6897 VSS.n1857 VSS.n1856 24.2744
R6898 VSS.n1856 VSS.n508 24.2744
R6899 VSS.n1847 VSS.n508 24.2744
R6900 VSS.n1847 VSS.n1846 24.2744
R6901 VSS.n1846 VSS.n1845 24.2744
R6902 VSS.n1845 VSS.n517 24.2744
R6903 VSS.n1836 VSS.n517 24.2744
R6904 VSS.n1836 VSS.n1835 24.2744
R6905 VSS.n1835 VSS.n1834 24.2744
R6906 VSS.n1834 VSS.n526 24.2744
R6907 VSS.n537 VSS.n526 24.2744
R6908 VSS.n1825 VSS.n537 24.2744
R6909 VSS.n1825 VSS.n1824 24.2744
R6910 VSS.n1824 VSS.n1823 24.2744
R6911 VSS.n1823 VSS.n538 24.2744
R6912 VSS.n1814 VSS.n538 24.2744
R6913 VSS.n1814 VSS.n1813 24.2744
R6914 VSS.n1813 VSS.n1812 24.2744
R6915 VSS.n1812 VSS.n547 24.2744
R6916 VSS.n1803 VSS.n547 24.2744
R6917 VSS.n1803 VSS.n1802 24.2744
R6918 VSS.n1802 VSS.n1801 24.2744
R6919 VSS.n1801 VSS.n556 24.2744
R6920 VSS.n1792 VSS.n1791 24.2744
R6921 VSS.n1791 VSS.n1790 24.2744
R6922 VSS.n1790 VSS.n566 24.2744
R6923 VSS.n1781 VSS.n566 24.2744
R6924 VSS.n1780 VSS.n1779 24.2744
R6925 VSS.n1779 VSS.n575 24.2744
R6926 VSS.n1770 VSS.n575 24.2744
R6927 VSS.n1770 VSS.n1769 24.2744
R6928 VSS.n1769 VSS.n1768 24.2744
R6929 VSS.n1768 VSS.n582 24.2744
R6930 VSS.n1759 VSS.n582 24.2744
R6931 VSS.n1759 VSS.n1758 24.2744
R6932 VSS.n1758 VSS.n1757 24.2744
R6933 VSS.n1757 VSS.n591 24.2744
R6934 VSS.n1748 VSS.n591 24.2744
R6935 VSS.n1748 VSS.n1747 24.2744
R6936 VSS.n1747 VSS.n1746 24.2744
R6937 VSS.n1746 VSS.n600 24.2744
R6938 VSS.n1737 VSS.n600 24.2744
R6939 VSS.n1737 VSS.n1736 24.2744
R6940 VSS.n1736 VSS.n1735 24.2744
R6941 VSS.n1735 VSS.n609 24.2744
R6942 VSS.n619 VSS.n609 24.2744
R6943 VSS.n1725 VSS.n619 24.2744
R6944 VSS.n1725 VSS.n1724 24.2744
R6945 VSS.n1724 VSS.n1723 24.2744
R6946 VSS.n1723 VSS.n620 24.2744
R6947 VSS.n1714 VSS.n620 24.2744
R6948 VSS.n1714 VSS.n1713 24.2744
R6949 VSS.n1713 VSS.n1712 24.2744
R6950 VSS.n1712 VSS.n629 24.2744
R6951 VSS.n1703 VSS.n629 24.2744
R6952 VSS.n1703 VSS.n1702 24.2744
R6953 VSS.n1702 VSS.n1701 24.2744
R6954 VSS.n1701 VSS.n638 24.2744
R6955 VSS.n1613 VSS.n1612 24.2744
R6956 VSS.n1612 VSS.n1611 24.2744
R6957 VSS.n1611 VSS.n662 24.2744
R6958 VSS.n1602 VSS.n662 24.2744
R6959 VSS.n1601 VSS.n1600 24.2744
R6960 VSS.n1600 VSS.n673 24.2744
R6961 VSS.n1591 VSS.n673 24.2744
R6962 VSS.n1590 VSS.n1589 24.2744
R6963 VSS.n1589 VSS.n686 24.2744
R6964 VSS.n1381 VSS.n686 24.2744
R6965 VSS.n1579 VSS.n1578 24.2744
R6966 VSS.n1578 VSS.n1577 24.2744
R6967 VSS.n1577 VSS.n699 24.2744
R6968 VSS.n1286 VSS.n699 24.2744
R6969 VSS.n1402 VSS.n1276 24.2744
R6970 VSS.n1413 VSS.n1276 24.2744
R6971 VSS.n1413 VSS.n1277 24.2744
R6972 VSS.n1424 VSS.n1247 24.2744
R6973 VSS.n1435 VSS.n1247 24.2744
R6974 VSS.n1435 VSS.n1241 24.2744
R6975 VSS.n1445 VSS.n1241 24.2744
R6976 VSS.n1455 VSS.n1235 24.2744
R6977 VSS.n1455 VSS.n1227 24.2744
R6978 VSS.n1465 VSS.n1227 24.2744
R6979 VSS.n1475 VSS.n1221 24.2744
R6980 VSS.n1475 VSS.n743 24.2744
R6981 VSS.n1538 VSS.n743 24.2744
R6982 VSS.n1538 VSS.n1537 24.2744
R6983 VSS.n1536 VSS.n747 24.2744
R6984 VSS.n1527 VSS.n747 24.2744
R6985 VSS.n1527 VSS.n1526 24.2744
R6986 VSS.n1182 VSS.n763 24.2744
R6987 VSS.n1182 VSS.n1181 24.2744
R6988 VSS.n1181 VSS.n1180 24.2744
R6989 VSS.n1180 VSS.n773 24.2744
R6990 VSS.n1174 VSS.n773 24.2744
R6991 VSS.n1174 VSS.n1173 24.2744
R6992 VSS.n1173 VSS.n1172 24.2744
R6993 VSS.n1172 VSS.n784 24.2744
R6994 VSS.t4 VSS.n1536 23.9174
R6995 VSS.n1781 VSS.t2 23.5605
R6996 VSS.n1381 VSS.t20 23.2035
R6997 VSS.n322 VSS.n321 22.1783
R6998 VSS.n2156 VSS.n1 22.1783
R6999 VSS.n321 VSS.n320 22.175
R7000 VSS.n2151 VSS.n1 22.175
R7001 VSS.n1613 VSS.n654 22.1326
R7002 VSS.n1526 VSS.n1525 22.1326
R7003 VSS.n2144 VSS.n12 22.0174
R7004 VSS.n2123 VSS.n333 22.0174
R7005 VSS.n137 VSS.n136 21.9321
R7006 VSS.n1263 VSS.n1253 21.9321
R7007 VSS.n1568 VSS.n707 21.9321
R7008 VSS.n723 VSS.n722 21.9321
R7009 VSS.n1551 VSS.n1550 21.9321
R7010 VSS.n67 VSS.n66 21.9321
R7011 VSS.n105 VSS.n104 21.9321
R7012 VSS.n136 VSS.n133 21.9288
R7013 VSS.n1266 VSS.n1265 21.9288
R7014 VSS.n1571 VSS.n1570 21.9288
R7015 VSS.n720 VSS.n719 21.9288
R7016 VSS.n1548 VSS.n1547 21.9288
R7017 VSS.n66 VSS.n63 21.9288
R7018 VSS.n104 VSS.n100 21.9288
R7019 VSS.t6 VSS.n1601 21.0617
R7020 VSS.n1523 VSS.n1195 20.3798
R7021 VSS.n1264 VSS.t17 20.0005
R7022 VSS.n1264 VSS.t10 20.0005
R7023 VSS.n1569 VSS.t21 20.0005
R7024 VSS.n1569 VSS.t13 20.0005
R7025 VSS.n721 VSS.t7 20.0005
R7026 VSS.n721 VSS.t25 20.0005
R7027 VSS.n1549 VSS.t31 20.0005
R7028 VSS.n1549 VSS.t5 20.0005
R7029 VSS.t9 VSS.n1235 19.6338
R7030 VSS.n1921 VSS.t23 19.477
R7031 VSS.n1277 VSS.t16 18.9199
R7032 VSS.n1792 VSS.n565 15.7071
R7033 VSS.n1402 VSS.t12 15.3502
R7034 VSS.n533 VSS.n530 15.0074
R7035 VSS.n1783 VSS.n573 15.0074
R7036 VSS.n1733 VSS.n1732 15.0074
R7037 VSS.n1379 VSS.n1378 15.0074
R7038 VSS.n1457 VSS.n1233 15.0074
R7039 VSS.n1587 VSS.n1586 15.0074
R7040 VSS.n1453 VSS.n1452 15.0074
R7041 VSS.n943 VSS.n929 15.0074
R7042 VSS.n949 VSS.n929 15.0074
R7043 VSS.n1178 VSS.n1177 15.0074
R7044 VSS.n1177 VSS.n1176 15.0074
R7045 VSS.n1938 VSS.n431 15.0074
R7046 VSS.n1938 VSS.n429 15.0074
R7047 VSS.n1996 VSS.n409 15.0074
R7048 VSS.n1996 VSS.n1995 15.0074
R7049 VSS.n2050 VSS.n387 15.0074
R7050 VSS.n2050 VSS.n385 15.0074
R7051 VSS.n2107 VSS.n365 15.0074
R7052 VSS.n2107 VSS.n363 15.0074
R7053 VSS.n311 VSS.n310 15.0074
R7054 VSS.n310 VSS.n39 15.0074
R7055 VSS.n267 VSS.n80 15.0074
R7056 VSS.n262 VSS.n80 15.0074
R7057 VSS.n222 VSS.n221 15.0074
R7058 VSS.n221 VSS.n125 15.0074
R7059 VSS.n178 VSS.n167 15.0074
R7060 VSS.n173 VSS.n167 15.0074
R7061 VSS.n1465 VSS.t30 14.6362
R7062 VSS.n1832 VSS.n1831 14.566
R7063 VSS.n1828 VSS.n1827 14.566
R7064 VSS.n1784 VSS.n570 14.566
R7065 VSS.n1777 VSS.n577 14.566
R7066 VSS.n612 VSS.n611 14.566
R7067 VSS.n1731 VSS.n613 14.566
R7068 VSS.n1377 VSS.n1294 14.566
R7069 VSS.n1383 VSS.n1293 14.566
R7070 VSS.n1458 VSS.n1232 14.566
R7071 VSS.n1463 VSS.n1229 14.566
R7072 VSS.n689 VSS.n688 14.566
R7073 VSS.n1585 VSS.n690 14.566
R7074 VSS.n1451 VSS.n1237 14.566
R7075 VSS.n1467 VSS.n1225 14.566
R7076 VSS.t8 VSS.n1900 14.3962
R7077 VSS.n565 VSS.n482 14.3962
R7078 VSS.n944 VSS.n931 14.1246
R7079 VSS.n948 VSS.n927 14.1246
R7080 VSS.n777 VSS.n775 14.1246
R7081 VSS.n786 VSS.n782 14.1246
R7082 VSS.n1935 VSS.n1934 14.1246
R7083 VSS.n1944 VSS.n428 14.1246
R7084 VSS.n1989 VSS.n1988 14.1246
R7085 VSS.n2001 VSS.n407 14.1246
R7086 VSS.n2047 VSS.n2046 14.1246
R7087 VSS.n2056 VSS.n384 14.1246
R7088 VSS.n2101 VSS.n2100 14.1246
R7089 VSS.n2111 VSS.n2110 14.1246
R7090 VSS.n315 VSS.n37 14.1246
R7091 VSS.n307 VSS.n306 14.1246
R7092 VSS.n268 VSS.n78 14.1246
R7093 VSS.n261 VSS.n83 14.1246
R7094 VSS.n124 VSS.n122 14.1246
R7095 VSS.n218 VSS.n217 14.1246
R7096 VSS.n179 VSS.n164 14.1246
R7097 VSS.n172 VSS.n171 14.1246
R7098 VSS.n1633 VSS.n336 13.7371
R7099 VSS.n1698 VSS.n642 13.7371
R7100 VSS.n1925 VSS.n435 13.7371
R7101 VSS.n1865 VSS.n501 13.7371
R7102 VSS.n529 VSS.n528 13.6833
R7103 VSS.n540 VSS.n534 13.6833
R7104 VSS.n1788 VSS.n1787 13.6833
R7105 VSS.n1776 VSS.n578 13.6833
R7106 VSS.n1739 VSS.n607 13.6833
R7107 VSS.n1728 VSS.n1727 13.6833
R7108 VSS.n1373 VSS.n1372 13.6833
R7109 VSS.n1385 VSS.n1384 13.6833
R7110 VSS.n1443 VSS.n1442 13.6833
R7111 VSS.n1462 VSS.n1230 13.6833
R7112 VSS.n1593 VSS.n681 13.6833
R7113 VSS.n1582 VSS.n1581 13.6833
R7114 VSS.n1448 VSS.n1447 13.6833
R7115 VSS.n1468 VSS.n1223 13.6833
R7116 VSS.n2148 VSS.n2147 13.4787
R7117 VSS.n35 VSS.n16 13.4787
R7118 VSS.n937 VSS.n936 13.2419
R7119 VSS.n955 VSS.n926 13.2419
R7120 VSS.n778 VSS.n772 13.2419
R7121 VSS.n1170 VSS.n787 13.2419
R7122 VSS.n1930 VSS.n433 13.2419
R7123 VSS.n1946 VSS.n1945 13.2419
R7124 VSS.n1987 VSS.n411 13.2419
R7125 VSS.n2000 VSS.n405 13.2419
R7126 VSS.n390 VSS.n389 13.2419
R7127 VSS.n2058 VSS.n2057 13.2419
R7128 VSS.n2099 VSS.n367 13.2419
R7129 VSS.n2115 VSS.n361 13.2419
R7130 VSS.n316 VSS.n36 13.2419
R7131 VSS.n302 VSS.n41 13.2419
R7132 VSS.n272 VSS.n271 13.2419
R7133 VSS.n258 VSS.n257 13.2419
R7134 VSS.n227 VSS.n120 13.2419
R7135 VSS.n213 VSS.n128 13.2419
R7136 VSS.n183 VSS.n182 13.2419
R7137 VSS.n8 VSS.n6 13.2419
R7138 VSS.n1591 VSS.t24 13.2084
R7139 VSS.n1838 VSS.n524 12.8005
R7140 VSS.n1821 VSS.n541 12.8005
R7141 VSS.n569 VSS.n568 12.8005
R7142 VSS.n1773 VSS.n1772 12.8005
R7143 VSS.n1740 VSS.n604 12.8005
R7144 VSS.n622 VSS.n616 12.8005
R7145 VSS.n1371 VSS.n1370 12.8005
R7146 VSS.n1386 VSS.n1291 12.8005
R7147 VSS.n1441 VSS.n1243 12.8005
R7148 VSS.n1477 VSS.n1218 12.8005
R7149 VSS.n1594 VSS.n677 12.8005
R7150 VSS.n701 VSS.n693 12.8005
R7151 VSS.n1250 VSS.n1239 12.8005
R7152 VSS.n1473 VSS.n1471 12.8005
R7153 VSS.n1265 VSS.n1252 12.6288
R7154 VSS.n1263 VSS.n1262 12.6288
R7155 VSS.n1570 VSS.n706 12.6288
R7156 VSS.n1568 VSS.n1567 12.6288
R7157 VSS.n720 VSS.n714 12.6288
R7158 VSS.n722 VSS.n713 12.6288
R7159 VSS.n1548 VSS.n736 12.6288
R7160 VSS.n1550 VSS.n735 12.6288
R7161 VSS.n1321 VSS.n655 12.4883
R7162 VSS.n1351 VSS.n1350 12.4883
R7163 VSS.n1498 VSS.n1212 12.4883
R7164 VSS.n960 VSS.n924 12.4883
R7165 VSS.n932 VSS.n920 12.4883
R7166 VSS.n1185 VSS.n770 12.3591
R7167 VSS.n1169 VSS.n788 12.3591
R7168 VSS.n1951 VSS.n426 12.3591
R7169 VSS.n1984 VSS.n1983 12.3591
R7170 VSS.n2007 VSS.n404 12.3591
R7171 VSS.n2040 VSS.n2039 12.3591
R7172 VSS.n2063 VSS.n382 12.3591
R7173 VSS.n2096 VSS.n2095 12.3591
R7174 VSS.n301 VSS.n45 12.3591
R7175 VSS.n276 VSS.n74 12.3591
R7176 VSS.n87 VSS.n85 12.3591
R7177 VSS.n228 VSS.n117 12.3591
R7178 VSS.n212 VSS.n132 12.3591
R7179 VSS.n163 VSS.n161 12.3591
R7180 VSS.n1839 VSS.n521 11.9177
R7181 VSS.n1820 VSS.n542 11.9177
R7182 VSS.n1794 VSS.n563 11.9177
R7183 VSS.n584 VSS.n580 11.9177
R7184 VSS.n1744 VSS.n1743 11.9177
R7185 VSS.n1721 VSS.n623 11.9177
R7186 VSS.n1368 VSS.n1296 11.9177
R7187 VSS.n1390 VSS.n1389 11.9177
R7188 VSS.n1438 VSS.n1437 11.9177
R7189 VSS.n1478 VSS.n1216 11.9177
R7190 VSS.n1598 VSS.n1597 11.9177
R7191 VSS.n1575 VSS.n702 11.9177
R7192 VSS.n1433 VSS.n1432 11.9177
R7193 VSS.n1472 VSS.n739 11.9177
R7194 VSS.n1929 VSS.n435 11.9177
R7195 VSS.n2116 VSS.n336 11.9177
R7196 VSS.n1950 VSS.n424 11.4764
R7197 VSS.n414 VSS.n413 11.4764
R7198 VSS.n2009 VSS.n2008 11.4764
R7199 VSS.n2034 VSS.n392 11.4764
R7200 VSS.n2062 VSS.n380 11.4764
R7201 VSS.n370 VSS.n369 11.4764
R7202 VSS.n298 VSS.n297 11.4764
R7203 VSS.n277 VSS.n73 11.4764
R7204 VSS.n252 VSS.n89 11.4764
R7205 VSS.n232 VSS.n231 11.4764
R7206 VSS.n209 VSS.n208 11.4764
R7207 VSS.n188 VSS.n159 11.4764
R7208 VSS.t24 VSS.n1590 11.0665
R7209 VSS.n1843 VSS.n1842 11.035
R7210 VSS.n1817 VSS.n1816 11.035
R7211 VSS.n1795 VSS.n560 11.035
R7212 VSS.n1766 VSS.n585 11.035
R7213 VSS.n603 VSS.n602 11.035
R7214 VSS.n1720 VSS.n624 11.035
R7215 VSS.n1365 VSS.n1364 11.035
R7216 VSS.n1393 VSS.n1391 11.035
R7217 VSS.n1272 VSS.n1245 11.035
R7218 VSS.n1482 VSS.n1481 11.035
R7219 VSS.n676 VSS.n675 11.035
R7220 VSS.n1574 VSS.n703 11.035
R7221 VSS.n1427 VSS.n1249 11.035
R7222 VSS.n1541 VSS.n1540 11.035
R7223 VSS.n1332 VSS.n1315 10.6151
R7224 VSS.n1209 VSS.n1202 10.6151
R7225 VSS.n996 VSS.n906 10.6151
R7226 VSS.n996 VSS.n892 10.6151
R7227 VSS.n1149 VSS.n801 10.6151
R7228 VSS.n1149 VSS.n802 10.6151
R7229 VSS.n1000 VSS.n901 10.6151
R7230 VSS.n1000 VSS.n902 10.6151
R7231 VSS.n1145 VSS.n807 10.6151
R7232 VSS.n1145 VSS.n1144 10.6151
R7233 VSS.n350 VSS.n338 10.6151
R7234 VSS.n352 VSS.n350 10.6151
R7235 VSS.n1637 VSS.n1636 10.6151
R7236 VSS.n1637 VSS.n1631 10.6151
R7237 VSS.n1675 VSS.n1674 10.6151
R7238 VSS.n1674 VSS.n651 10.6151
R7239 VSS.n2131 VSS.n27 10.6151
R7240 VSS.n2131 VSS.n28 10.6151
R7241 VSS.n1918 VSS.n450 10.6151
R7242 VSS.n1918 VSS.n451 10.6151
R7243 VSS.n1872 VSS.n497 10.6151
R7244 VSS.n1872 VSS.n1871 10.6151
R7245 VSS.n1957 VSS.n423 10.5936
R7246 VSS.n1977 VSS.n1976 10.5936
R7247 VSS.n2014 VSS.n402 10.5936
R7248 VSS.n2035 VSS.n2033 10.5936
R7249 VSS.n2069 VSS.n379 10.5936
R7250 VSS.n2089 VSS.n2088 10.5936
R7251 VSS.n49 VSS.n47 10.5936
R7252 VSS.n62 VSS.n60 10.5936
R7253 VSS.n251 VSS.n90 10.5936
R7254 VSS.n116 VSS.n114 10.5936
R7255 VSS.n145 VSS.n143 10.5936
R7256 VSS.n189 VSS.n156 10.5936
R7257 VSS.n1333 VSS.n1314 10.3029
R7258 VSS.n1344 VSS.n1306 10.3029
R7259 VSS.n1513 VSS.n1512 10.3029
R7260 VSS.n1211 VSS.n1210 10.3029
R7261 VSS.n1861 VSS.n1860 10.1522
R7262 VSS.n520 VSS.n519 10.1522
R7263 VSS.n549 VSS.n545 10.1522
R7264 VSS.n1799 VSS.n1798 10.1522
R7265 VSS.n1765 VSS.n586 10.1522
R7266 VSS.n1750 VSS.n598 10.1522
R7267 VSS.n1717 VSS.n1716 10.1522
R7268 VSS.n641 VSS.n640 10.1522
R7269 VSS.n1363 VSS.n1362 10.1522
R7270 VSS.n1395 VSS.n1394 10.1522
R7271 VSS.n1422 VSS.n1421 10.1522
R7272 VSS.n1484 VSS.n1483 10.1522
R7273 VSS.n1604 VSS.n668 10.1522
R7274 VSS.n1284 VSS.n1283 10.1522
R7275 VSS.n1428 VSS.n1426 10.1522
R7276 VSS.n749 VSS.n740 10.1522
R7277 VSS.n976 VSS.n914 9.99074
R7278 VSS.n1010 VSS.n1009 9.99074
R7279 VSS.n1133 VSS.n1132 9.99074
R7280 VSS.n1158 VSS.n796 9.99074
R7281 VSS.n972 VSS.n971 9.99074
R7282 VSS.n1005 VSS.n898 9.99074
R7283 VSS.n1138 VSS.n1137 9.99074
R7284 VSS.n1143 VSS.n1141 9.99074
R7285 VSS.n343 VSS.n342 9.99074
R7286 VSS.n354 VSS.n353 9.99074
R7287 VSS.n1635 VSS.n1634 9.99074
R7288 VSS.n1641 VSS.n1640 9.99074
R7289 VSS.n1678 VSS.n1672 9.99074
R7290 VSS.n1689 VSS.n1688 9.99074
R7291 VSS.n2137 VSS.n20 9.99074
R7292 VSS.n2128 VSS.n2127 9.99074
R7293 VSS.n1924 VSS.n443 9.99074
R7294 VSS.n1915 VSS.n1914 9.99074
R7295 VSS.n1876 VSS.n1875 9.99074
R7296 VSS.n1869 VSS.n1868 9.99074
R7297 VSS.n1959 VSS.n1958 9.71084
R7298 VSS.n1971 VSS.n416 9.71084
R7299 VSS.n2013 VSS.n400 9.71084
R7300 VSS.n395 VSS.n394 9.71084
R7301 VSS.n2071 VSS.n2070 9.71084
R7302 VSS.n2083 VSS.n372 9.71084
R7303 VSS.n292 VSS.n51 9.71084
R7304 VSS.n282 VSS.n281 9.71084
R7305 VSS.n248 VSS.n247 9.71084
R7306 VSS.n237 VSS.n112 9.71084
R7307 VSS.n203 VSS.n147 9.71084
R7308 VSS.n193 VSS.n192 9.71084
R7309 VSS.n1326 VSS.n1325 9.67855
R7310 VSS.n1343 VSS.n1304 9.67855
R7311 VSS.n1516 VSS.n1201 9.67855
R7312 VSS.n1505 VSS.n1504 9.67855
R7313 VSS.t30 VSS.n1221 9.63866
R7314 VSS.n977 VSS.n913 9.36635
R7315 VSS.n894 VSS.n893 9.36635
R7316 VSS.n1118 VSS.n813 9.36635
R7317 VSS.n1157 VSS.n797 9.36635
R7318 VSS.n970 VSS.n918 9.36635
R7319 VSS.n1004 VSS.n899 9.36635
R7320 VSS.n827 VSS.n809 9.36635
R7321 VSS.n1191 VSS.n766 9.36635
R7322 VSS.n344 VSS.n341 9.36635
R7323 VSS.n356 VSS.n355 9.36635
R7324 VSS.n1643 VSS.n1642 9.36635
R7325 VSS.n1679 VSS.n1622 9.36635
R7326 VSS.n2138 VSS.n17 9.36635
R7327 VSS.n437 VSS.n328 9.36635
R7328 VSS.n460 VSS.n453 9.36635
R7329 VSS.n496 VSS.n495 9.36635
R7330 VSS.n1862 VSS.n1861 9.3005
R7331 VSS.n505 VSS.n504 9.3005
R7332 VSS.n513 VSS.n511 9.3005
R7333 VSS.n1853 VSS.n1852 9.3005
R7334 VSS.n1851 VSS.n1850 9.3005
R7335 VSS.n515 VSS.n514 9.3005
R7336 VSS.n522 VSS.n520 9.3005
R7337 VSS.n1842 VSS.n1841 9.3005
R7338 VSS.n1840 VSS.n1839 9.3005
R7339 VSS.n524 VSS.n523 9.3005
R7340 VSS.n531 VSS.n529 9.3005
R7341 VSS.n1831 VSS.n1830 9.3005
R7342 VSS.n1829 VSS.n1828 9.3005
R7343 VSS.n534 VSS.n532 9.3005
R7344 VSS.n543 VSS.n541 9.3005
R7345 VSS.n1820 VSS.n1819 9.3005
R7346 VSS.n1818 VSS.n1817 9.3005
R7347 VSS.n545 VSS.n544 9.3005
R7348 VSS.n552 VSS.n550 9.3005
R7349 VSS.n1809 VSS.n1808 9.3005
R7350 VSS.n1807 VSS.n1806 9.3005
R7351 VSS.n554 VSS.n553 9.3005
R7352 VSS.n561 VSS.n559 9.3005
R7353 VSS.n1798 VSS.n1797 9.3005
R7354 VSS.n1796 VSS.n1795 9.3005
R7355 VSS.n563 VSS.n562 9.3005
R7356 VSS.n571 VSS.n569 9.3005
R7357 VSS.n1787 VSS.n1786 9.3005
R7358 VSS.n1785 VSS.n1784 9.3005
R7359 VSS.n577 VSS.n572 9.3005
R7360 VSS.n1776 VSS.n1775 9.3005
R7361 VSS.n1774 VSS.n1773 9.3005
R7362 VSS.n580 VSS.n579 9.3005
R7363 VSS.n587 VSS.n585 9.3005
R7364 VSS.n1765 VSS.n1764 9.3005
R7365 VSS.n1763 VSS.n1762 9.3005
R7366 VSS.n589 VSS.n588 9.3005
R7367 VSS.n596 VSS.n594 9.3005
R7368 VSS.n1754 VSS.n1753 9.3005
R7369 VSS.n1752 VSS.n1751 9.3005
R7370 VSS.n598 VSS.n597 9.3005
R7371 VSS.n605 VSS.n603 9.3005
R7372 VSS.n1743 VSS.n1742 9.3005
R7373 VSS.n1741 VSS.n1740 9.3005
R7374 VSS.n607 VSS.n606 9.3005
R7375 VSS.n614 VSS.n612 9.3005
R7376 VSS.n1731 VSS.n1730 9.3005
R7377 VSS.n1729 VSS.n1728 9.3005
R7378 VSS.n616 VSS.n615 9.3005
R7379 VSS.n625 VSS.n623 9.3005
R7380 VSS.n1720 VSS.n1719 9.3005
R7381 VSS.n1718 VSS.n1717 9.3005
R7382 VSS.n627 VSS.n626 9.3005
R7383 VSS.n634 VSS.n632 9.3005
R7384 VSS.n1709 VSS.n1708 9.3005
R7385 VSS.n1707 VSS.n1706 9.3005
R7386 VSS.n636 VSS.n635 9.3005
R7387 VSS.n643 VSS.n641 9.3005
R7388 VSS.n1354 VSS.n1353 9.3005
R7389 VSS.n1356 VSS.n1300 9.3005
R7390 VSS.n1359 VSS.n1358 9.3005
R7391 VSS.n1361 VSS.n1360 9.3005
R7392 VSS.n1363 VSS.n1297 9.3005
R7393 VSS.n1366 VSS.n1365 9.3005
R7394 VSS.n1368 VSS.n1367 9.3005
R7395 VSS.n1371 VSS.n1295 9.3005
R7396 VSS.n1374 VSS.n1373 9.3005
R7397 VSS.n1377 VSS.n1376 9.3005
R7398 VSS.n1375 VSS.n1293 9.3005
R7399 VSS.n1384 VSS.n1292 9.3005
R7400 VSS.n1387 VSS.n1386 9.3005
R7401 VSS.n1389 VSS.n1388 9.3005
R7402 VSS.n1391 VSS.n1290 9.3005
R7403 VSS.n1396 VSS.n1395 9.3005
R7404 VSS.n1397 VSS.n1288 9.3005
R7405 VSS.n1399 VSS.n1398 9.3005
R7406 VSS.n1274 VSS.n1273 9.3005
R7407 VSS.n1418 VSS.n1417 9.3005
R7408 VSS.n1419 VSS.n1271 9.3005
R7409 VSS.n1421 VSS.n1420 9.3005
R7410 VSS.n1245 VSS.n1244 9.3005
R7411 VSS.n1439 VSS.n1438 9.3005
R7412 VSS.n1441 VSS.n1440 9.3005
R7413 VSS.n1442 VSS.n1231 9.3005
R7414 VSS.n1459 VSS.n1458 9.3005
R7415 VSS.n1460 VSS.n1229 9.3005
R7416 VSS.n1462 VSS.n1461 9.3005
R7417 VSS.n1218 VSS.n1217 9.3005
R7418 VSS.n1479 VSS.n1478 9.3005
R7419 VSS.n1481 VSS.n1480 9.3005
R7420 VSS.n1483 VSS.n1215 9.3005
R7421 VSS.n1486 VSS.n1485 9.3005
R7422 VSS.n1488 VSS.n1487 9.3005
R7423 VSS.n1491 VSS.n1213 9.3005
R7424 VSS.n1495 VSS.n1494 9.3005
R7425 VSS.n1254 VSS.n1252 9.3005
R7426 VSS.n1262 VSS.n1261 9.3005
R7427 VSS.n1558 VSS.n706 9.3005
R7428 VSS.n1567 VSS.n1566 9.3005
R7429 VSS.n716 VSS.n714 9.3005
R7430 VSS.n713 VSS.n712 9.3005
R7431 VSS.n1320 VSS.n655 9.3005
R7432 VSS.n1322 VSS.n1321 9.3005
R7433 VSS.n1324 VSS.n1323 9.3005
R7434 VSS.n1325 VSS.n1312 9.3005
R7435 VSS.n1334 VSS.n1333 9.3005
R7436 VSS.n1307 VSS.n1306 9.3005
R7437 VSS.n1343 VSS.n1342 9.3005
R7438 VSS.n1341 VSS.n1303 9.3005
R7439 VSS.n1350 VSS.n1302 9.3005
R7440 VSS.n1352 VSS.n1351 9.3005
R7441 VSS.n1545 VSS.n736 9.3005
R7442 VSS.n735 VSS.n734 9.3005
R7443 VSS.n1498 VSS.n1497 9.3005
R7444 VSS.n1501 VSS.n1206 9.3005
R7445 VSS.n1506 VSS.n1505 9.3005
R7446 VSS.n1210 VSS.n1204 9.3005
R7447 VSS.n1519 VSS.n1196 9.3005
R7448 VSS.n1518 VSS.n1517 9.3005
R7449 VSS.n1201 VSS.n1198 9.3005
R7450 VSS.n1512 VSS.n1511 9.3005
R7451 VSS.n1496 VSS.n1212 9.3005
R7452 VSS.n1319 VSS.n1318 9.3005
R7453 VSS.n666 VSS.n664 9.3005
R7454 VSS.n1608 VSS.n1607 9.3005
R7455 VSS.n1606 VSS.n1605 9.3005
R7456 VSS.n668 VSS.n667 9.3005
R7457 VSS.n678 VSS.n676 9.3005
R7458 VSS.n1597 VSS.n1596 9.3005
R7459 VSS.n1595 VSS.n1594 9.3005
R7460 VSS.n681 VSS.n680 9.3005
R7461 VSS.n691 VSS.n689 9.3005
R7462 VSS.n1585 VSS.n1584 9.3005
R7463 VSS.n1583 VSS.n1582 9.3005
R7464 VSS.n693 VSS.n692 9.3005
R7465 VSS.n1572 VSS.n702 9.3005
R7466 VSS.n1574 VSS.n1573 9.3005
R7467 VSS.n1283 VSS.n704 9.3005
R7468 VSS.n1282 VSS.n1281 9.3005
R7469 VSS.n1407 VSS.n1406 9.3005
R7470 VSS.n1408 VSS.n1279 9.3005
R7471 VSS.n1410 VSS.n1409 9.3005
R7472 VSS.n1268 VSS.n1267 9.3005
R7473 VSS.n1429 VSS.n1428 9.3005
R7474 VSS.n1430 VSS.n1249 9.3005
R7475 VSS.n1432 VSS.n1431 9.3005
R7476 VSS.n1239 VSS.n1238 9.3005
R7477 VSS.n1449 VSS.n1448 9.3005
R7478 VSS.n1451 VSS.n1450 9.3005
R7479 VSS.n1225 VSS.n1224 9.3005
R7480 VSS.n1469 VSS.n1468 9.3005
R7481 VSS.n1471 VSS.n1470 9.3005
R7482 VSS.n1472 VSS.n737 9.3005
R7483 VSS.n1542 VSS.n1541 9.3005
R7484 VSS.n740 VSS.n738 9.3005
R7485 VSS.n752 VSS.n750 9.3005
R7486 VSS.n1533 VSS.n1532 9.3005
R7487 VSS.n1531 VSS.n1530 9.3005
R7488 VSS.n754 VSS.n753 9.3005
R7489 VSS.n1521 VSS.n1520 9.3005
R7490 VSS.n935 VSS.n934 9.3005
R7491 VSS.n936 VSS.n930 9.3005
R7492 VSS.n945 VSS.n944 9.3005
R7493 VSS.n946 VSS.n929 9.3005
R7494 VSS.n948 VSS.n947 9.3005
R7495 VSS.n926 VSS.n925 9.3005
R7496 VSS.n957 VSS.n956 9.3005
R7497 VSS.n986 VSS.n985 9.3005
R7498 VSS.n984 VSS.n983 9.3005
R7499 VSS.n994 VSS.n887 9.3005
R7500 VSS.n1013 VSS.n1012 9.3005
R7501 VSS.n890 VSS.n885 9.3005
R7502 VSS.n1018 VSS.n1017 9.3005
R7503 VSS.n1024 VSS.n863 9.3005
R7504 VSS.n1046 VSS.n1045 9.3005
R7505 VSS.n865 VSS.n861 9.3005
R7506 VSS.n1051 VSS.n1050 9.3005
R7507 VSS.n1061 VSS.n842 9.3005
R7508 VSS.n1083 VSS.n1082 9.3005
R7509 VSS.n1054 VSS.n840 9.3005
R7510 VSS.n1090 VSS.n1089 9.3005
R7511 VSS.n1088 VSS.n835 9.3005
R7512 VSS.n837 VSS.n817 9.3005
R7513 VSS.n1122 VSS.n1121 9.3005
R7514 VSS.n820 VSS.n815 9.3005
R7515 VSS.n1129 VSS.n1128 9.3005
R7516 VSS.n1127 VSS.n800 9.3005
R7517 VSS.n1165 VSS.n791 9.3005
R7518 VSS.n1155 VSS.n792 9.3005
R7519 VSS.n1157 VSS.n1156 9.3005
R7520 VSS.n1154 VSS.n796 9.3005
R7521 VSS.n1150 VSS.n1149 9.3005
R7522 VSS.n1063 VSS.n1062 9.3005
R7523 VSS.n858 VSS.n857 9.3005
R7524 VSS.n869 VSS.n860 9.3005
R7525 VSS.n1044 VSS.n1043 9.3005
R7526 VSS.n1026 VSS.n1025 9.3005
R7527 VSS.n882 VSS.n881 9.3005
R7528 VSS.n894 VSS.n884 9.3005
R7529 VSS.n1011 VSS.n1010 9.3005
R7530 VSS.n996 VSS.n995 9.3005
R7531 VSS.n960 VSS.n959 9.3005
R7532 VSS.n961 VSS.n912 9.3005
R7533 VSS.n978 VSS.n977 9.3005
R7534 VSS.n914 VSS.n907 9.3005
R7535 VSS.n1081 VSS.n1080 9.3005
R7536 VSS.n847 VSS.n839 9.3005
R7537 VSS.n1092 VSS.n833 9.3005
R7538 VSS.n1101 VSS.n1100 9.3005
R7539 VSS.n836 VSS.n822 9.3005
R7540 VSS.n1120 VSS.n1119 9.3005
R7541 VSS.n819 VSS.n813 9.3005
R7542 VSS.n1132 VSS.n1131 9.3005
R7543 VSS.n958 VSS.n924 9.3005
R7544 VSS.n1167 VSS.n1166 9.3005
R7545 VSS.n1169 VSS.n1168 9.3005
R7546 VSS.n790 VSS.n787 9.3005
R7547 VSS.n789 VSS.n782 9.3005
R7548 VSS.n1177 VSS.n781 9.3005
R7549 VSS.n780 VSS.n775 9.3005
R7550 VSS.n779 VSS.n778 9.3005
R7551 VSS.n776 VSS.n770 9.3005
R7552 VSS.n1186 VSS.n769 9.3005
R7553 VSS.n933 VSS.n932 9.3005
R7554 VSS.n920 VSS.n919 9.3005
R7555 VSS.n968 VSS.n967 9.3005
R7556 VSS.n970 VSS.n969 9.3005
R7557 VSS.n971 VSS.n900 9.3005
R7558 VSS.n1001 VSS.n1000 9.3005
R7559 VSS.n1002 VSS.n898 9.3005
R7560 VSS.n1004 VSS.n1003 9.3005
R7561 VSS.n877 VSS.n876 9.3005
R7562 VSS.n1034 VSS.n1033 9.3005
R7563 VSS.n1035 VSS.n874 9.3005
R7564 VSS.n1037 VSS.n1036 9.3005
R7565 VSS.n854 VSS.n853 9.3005
R7566 VSS.n1071 VSS.n1070 9.3005
R7567 VSS.n1072 VSS.n851 9.3005
R7568 VSS.n1074 VSS.n1073 9.3005
R7569 VSS.n829 VSS.n828 9.3005
R7570 VSS.n1109 VSS.n1108 9.3005
R7571 VSS.n1110 VSS.n826 9.3005
R7572 VSS.n1112 VSS.n1111 9.3005
R7573 VSS.n809 VSS.n808 9.3005
R7574 VSS.n1139 VSS.n1138 9.3005
R7575 VSS.n1145 VSS.n1140 9.3005
R7576 VSS.n1143 VSS.n1142 9.3005
R7577 VSS.n768 VSS.n766 9.3005
R7578 VSS.n1190 VSS.n1189 9.3005
R7579 VSS.n1188 VSS.n1187 9.3005
R7580 VSS.n279 VSS.n62 9.3005
R7581 VSS.n278 VSS.n277 9.3005
R7582 VSS.n74 VSS.n72 9.3005
R7583 VSS.n271 VSS.n270 9.3005
R7584 VSS.n269 VSS.n268 9.3005
R7585 VSS.n80 VSS.n79 9.3005
R7586 VSS.n261 VSS.n260 9.3005
R7587 VSS.n259 VSS.n258 9.3005
R7588 VSS.n85 VSS.n84 9.3005
R7589 VSS.n91 VSS.n89 9.3005
R7590 VSS.n251 VSS.n250 9.3005
R7591 VSS.n249 VSS.n248 9.3005
R7592 VSS.n93 VSS.n92 9.3005
R7593 VSS.n99 VSS.n97 9.3005
R7594 VSS.n241 VSS.n240 9.3005
R7595 VSS.n239 VSS.n238 9.3005
R7596 VSS.n112 VSS.n111 9.3005
R7597 VSS.n118 VSS.n116 9.3005
R7598 VSS.n231 VSS.n230 9.3005
R7599 VSS.n229 VSS.n228 9.3005
R7600 VSS.n120 VSS.n119 9.3005
R7601 VSS.n126 VSS.n124 9.3005
R7602 VSS.n221 VSS.n220 9.3005
R7603 VSS.n219 VSS.n218 9.3005
R7604 VSS.n128 VSS.n127 9.3005
R7605 VSS.n212 VSS.n211 9.3005
R7606 VSS.n210 VSS.n209 9.3005
R7607 VSS.n149 VSS.n147 9.3005
R7608 VSS.n202 VSS.n201 9.3005
R7609 VSS.n200 VSS.n199 9.3005
R7610 VSS.n151 VSS.n150 9.3005
R7611 VSS.n157 VSS.n155 9.3005
R7612 VSS.n192 VSS.n191 9.3005
R7613 VSS.n190 VSS.n189 9.3005
R7614 VSS.n159 VSS.n158 9.3005
R7615 VSS.n165 VSS.n163 9.3005
R7616 VSS.n182 VSS.n181 9.3005
R7617 VSS.n180 VSS.n179 9.3005
R7618 VSS.n167 VSS.n166 9.3005
R7619 VSS.n172 VSS.n5 9.3005
R7620 VSS.n143 VSS.n142 9.3005
R7621 VSS.n2150 VSS.n6 9.3005
R7622 VSS.n2149 VSS.n2148 9.3005
R7623 VSS.n644 VSS.n642 9.3005
R7624 VSS.n1690 VSS.n1689 9.3005
R7625 VSS.n1674 VSS.n649 9.3005
R7626 VSS.n1657 VSS.n1625 9.3005
R7627 VSS.n1655 VSS.n1654 9.3005
R7628 VSS.n1653 VSS.n1652 9.3005
R7629 VSS.n1650 VSS.n1627 9.3005
R7630 VSS.n1647 VSS.n1646 9.3005
R7631 VSS.n1645 VSS.n1644 9.3005
R7632 VSS.n1642 VSS.n1629 9.3005
R7633 VSS.n1640 VSS.n1639 9.3005
R7634 VSS.n1638 VSS.n1637 9.3005
R7635 VSS.n2120 VSS.n2119 9.3005
R7636 VSS.n358 VSS.n335 9.3005
R7637 VSS.n2147 VSS.n7 9.3005
R7638 VSS.n340 VSS.n9 9.3005
R7639 VSS.n345 VSS.n344 9.3005
R7640 VSS.n342 VSS.n339 9.3005
R7641 VSS.n350 VSS.n349 9.3005
R7642 VSS.n353 VSS.n337 9.3005
R7643 VSS.n357 VSS.n356 9.3005
R7644 VSS.n1633 VSS.n359 9.3005
R7645 VSS.n1635 VSS.n1632 9.3005
R7646 VSS.n1661 VSS.n1660 9.3005
R7647 VSS.n1663 VSS.n1662 9.3005
R7648 VSS.n1665 VSS.n1623 9.3005
R7649 VSS.n1669 VSS.n1668 9.3005
R7650 VSS.n1670 VSS.n1621 9.3005
R7651 VSS.n1682 VSS.n1681 9.3005
R7652 VSS.n1680 VSS.n1679 9.3005
R7653 VSS.n1672 VSS.n1671 9.3005
R7654 VSS.n1698 VSS.n1697 9.3005
R7655 VSS.n1929 VSS.n1928 9.3005
R7656 VSS.n433 VSS.n432 9.3005
R7657 VSS.n1936 VSS.n1935 9.3005
R7658 VSS.n1938 VSS.n1937 9.3005
R7659 VSS.n428 VSS.n427 9.3005
R7660 VSS.n1947 VSS.n1946 9.3005
R7661 VSS.n1948 VSS.n426 9.3005
R7662 VSS.n1950 VSS.n1949 9.3005
R7663 VSS.n423 VSS.n422 9.3005
R7664 VSS.n1960 VSS.n1959 9.3005
R7665 VSS.n1961 VSS.n421 9.3005
R7666 VSS.n1963 VSS.n1962 9.3005
R7667 VSS.n418 VSS.n417 9.3005
R7668 VSS.n1973 VSS.n1972 9.3005
R7669 VSS.n1974 VSS.n416 9.3005
R7670 VSS.n1976 VSS.n1975 9.3005
R7671 VSS.n413 VSS.n412 9.3005
R7672 VSS.n1985 VSS.n1984 9.3005
R7673 VSS.n1987 VSS.n1986 9.3005
R7674 VSS.n1988 VSS.n408 9.3005
R7675 VSS.n1997 VSS.n1996 9.3005
R7676 VSS.n1998 VSS.n407 9.3005
R7677 VSS.n2000 VSS.n1999 9.3005
R7678 VSS.n404 VSS.n403 9.3005
R7679 VSS.n2010 VSS.n2009 9.3005
R7680 VSS.n2011 VSS.n402 9.3005
R7681 VSS.n2013 VSS.n2012 9.3005
R7682 VSS.n399 VSS.n398 9.3005
R7683 VSS.n2023 VSS.n2022 9.3005
R7684 VSS.n2024 VSS.n397 9.3005
R7685 VSS.n2026 VSS.n2025 9.3005
R7686 VSS.n394 VSS.n393 9.3005
R7687 VSS.n2036 VSS.n2035 9.3005
R7688 VSS.n2037 VSS.n392 9.3005
R7689 VSS.n2039 VSS.n2038 9.3005
R7690 VSS.n389 VSS.n388 9.3005
R7691 VSS.n2048 VSS.n2047 9.3005
R7692 VSS.n2050 VSS.n2049 9.3005
R7693 VSS.n384 VSS.n383 9.3005
R7694 VSS.n2059 VSS.n2058 9.3005
R7695 VSS.n2060 VSS.n382 9.3005
R7696 VSS.n2062 VSS.n2061 9.3005
R7697 VSS.n379 VSS.n378 9.3005
R7698 VSS.n2072 VSS.n2071 9.3005
R7699 VSS.n2073 VSS.n377 9.3005
R7700 VSS.n2075 VSS.n2074 9.3005
R7701 VSS.n374 VSS.n373 9.3005
R7702 VSS.n2085 VSS.n2084 9.3005
R7703 VSS.n2086 VSS.n372 9.3005
R7704 VSS.n2088 VSS.n2087 9.3005
R7705 VSS.n369 VSS.n368 9.3005
R7706 VSS.n2097 VSS.n2096 9.3005
R7707 VSS.n2099 VSS.n2098 9.3005
R7708 VSS.n2100 VSS.n364 9.3005
R7709 VSS.n2108 VSS.n2107 9.3005
R7710 VSS.n2110 VSS.n2109 9.3005
R7711 VSS.n361 VSS.n360 9.3005
R7712 VSS.n2117 VSS.n2116 9.3005
R7713 VSS.n438 VSS.n436 9.3005
R7714 VSS.n328 VSS.n327 9.3005
R7715 VSS.n2129 VSS.n2128 9.3005
R7716 VSS.n2131 VSS.n2130 9.3005
R7717 VSS.n18 VSS.n16 9.3005
R7718 VSS.n2141 VSS.n2140 9.3005
R7719 VSS.n2139 VSS.n2138 9.3005
R7720 VSS.n29 VSS.n20 9.3005
R7721 VSS.n441 VSS.n440 9.3005
R7722 VSS.n1926 VSS.n1925 9.3005
R7723 VSS.n443 VSS.n442 9.3005
R7724 VSS.n1918 VSS.n1917 9.3005
R7725 VSS.n1916 VSS.n1915 9.3005
R7726 VSS.n453 VSS.n452 9.3005
R7727 VSS.n463 VSS.n461 9.3005
R7728 VSS.n1907 VSS.n1906 9.3005
R7729 VSS.n1905 VSS.n1904 9.3005
R7730 VSS.n465 VSS.n464 9.3005
R7731 VSS.n475 VSS.n473 9.3005
R7732 VSS.n1896 VSS.n1895 9.3005
R7733 VSS.n1894 VSS.n1893 9.3005
R7734 VSS.n477 VSS.n476 9.3005
R7735 VSS.n487 VSS.n485 9.3005
R7736 VSS.n1885 VSS.n1884 9.3005
R7737 VSS.n1883 VSS.n1882 9.3005
R7738 VSS.n489 VSS.n488 9.3005
R7739 VSS.n498 VSS.n496 9.3005
R7740 VSS.n1875 VSS.n1874 9.3005
R7741 VSS.n1873 VSS.n1872 9.3005
R7742 VSS.n1869 VSS.n499 9.3005
R7743 VSS.n1863 VSS.n501 9.3005
R7744 VSS.n1865 VSS.n1864 9.3005
R7745 VSS.n35 VSS.n33 9.3005
R7746 VSS.n37 VSS.n34 9.3005
R7747 VSS.n310 VSS.n309 9.3005
R7748 VSS.n308 VSS.n307 9.3005
R7749 VSS.n41 VSS.n40 9.3005
R7750 VSS.n301 VSS.n300 9.3005
R7751 VSS.n299 VSS.n298 9.3005
R7752 VSS.n47 VSS.n46 9.3005
R7753 VSS.n53 VSS.n51 9.3005
R7754 VSS.n291 VSS.n290 9.3005
R7755 VSS.n289 VSS.n288 9.3005
R7756 VSS.n55 VSS.n54 9.3005
R7757 VSS.n61 VSS.n59 9.3005
R7758 VSS.n281 VSS.n280 9.3005
R7759 VSS.n317 VSS.n316 9.3005
R7760 VSS.n510 VSS.n505 9.26947
R7761 VSS.n1849 VSS.n515 9.26947
R7762 VSS.n1810 VSS.n550 9.26947
R7763 VSS.n559 VSS.n558 9.26947
R7764 VSS.n1762 VSS.n1761 9.26947
R7765 VSS.n1751 VSS.n595 9.26947
R7766 VSS.n631 VSS.n627 9.26947
R7767 VSS.n1705 VSS.n636 9.26947
R7768 VSS.n1361 VSS.n1299 9.26947
R7769 VSS.n1400 VSS.n1288 9.26947
R7770 VSS.n1416 VSS.n1271 9.26947
R7771 VSS.n1485 VSS.n1214 9.26947
R7772 VSS.n1605 VSS.n665 9.26947
R7773 VSS.n1404 VSS.n1282 9.26947
R7774 VSS.n1280 VSS.n1268 9.26947
R7775 VSS.n1534 VSS.n750 9.26947
R7776 VSS.n1521 VSS.n1197 9.26947
R7777 VSS.n985 VSS.n980 9.2683
R7778 VSS.n1127 VSS.n1126 9.2683
R7779 VSS.n1324 VSS.n1316 9.05416
R7780 VSS.n1349 VSS.n1303 9.05416
R7781 VSS.n1517 VSS.n1200 9.05416
R7782 VSS.n1501 VSS.n1500 9.05416
R7783 VSS.n1286 VSS.t12 8.92473
R7784 VSS.n1964 VSS.n421 8.82809
R7785 VSS.n1972 VSS.n1970 8.82809
R7786 VSS.n2020 VSS.n399 8.82809
R7787 VSS.n2027 VSS.n2026 8.82809
R7788 VSS.n2076 VSS.n377 8.82809
R7789 VSS.n2084 VSS.n2082 8.82809
R7790 VSS.n291 VSS.n52 8.82809
R7791 VSS.n59 VSS.n57 8.82809
R7792 VSS.n95 VSS.n93 8.82809
R7793 VSS.n238 VSS.n98 8.82809
R7794 VSS.n202 VSS.n148 8.82809
R7795 VSS.n155 VSS.n153 8.82809
R7796 VSS.n962 VSS.n961 8.74196
R7797 VSS.n1027 VSS.n881 8.74196
R7798 VSS.n1119 VSS.n1117 8.74196
R7799 VSS.n1164 VSS.n792 8.74196
R7800 VSS.n967 VSS.n966 8.74196
R7801 VSS.n1031 VSS.n877 8.74196
R7802 VSS.n1113 VSS.n1112 8.74196
R7803 VSS.n1190 VSS.n767 8.74196
R7804 VSS.n2146 VSS.n9 8.74196
R7805 VSS.n2121 VSS.n335 8.74196
R7806 VSS.n1644 VSS.n1628 8.74196
R7807 VSS.n1683 VSS.n1682 8.74196
R7808 VSS.n2142 VSS.n2141 8.74196
R7809 VSS.n439 VSS.n438 8.74196
R7810 VSS.n1908 VSS.n461 8.74196
R7811 VSS.n1881 VSS.n489 8.74196
R7812 VSS.n565 VSS.n556 8.56776
R7813 VSS.n1854 VSS.n511 8.38671
R7814 VSS.n1850 VSS.n512 8.38671
R7815 VSS.n1809 VSS.n551 8.38671
R7816 VSS.n1805 VSS.n554 8.38671
R7817 VSS.n593 VSS.n589 8.38671
R7818 VSS.n1755 VSS.n1754 8.38671
R7819 VSS.n1710 VSS.n632 8.38671
R7820 VSS.n1706 VSS.n633 8.38671
R7821 VSS.n1355 VSS.n1354 8.38671
R7822 VSS.n1358 VSS.n1357 8.38671
R7823 VSS.n1399 VSS.n1289 8.38671
R7824 VSS.n1417 VSS.n1415 8.38671
R7825 VSS.n1490 VSS.n1488 8.38671
R7826 VSS.n1494 VSS.n1492 8.38671
R7827 VSS.n1318 VSS.n1317 8.38671
R7828 VSS.n1609 VSS.n1608 8.38671
R7829 VSS.n1406 VSS.n1405 8.38671
R7830 VSS.n1411 VSS.n1410 8.38671
R7831 VSS.n1533 VSS.n751 8.38671
R7832 VSS.n1529 VSS.n754 8.38671
R7833 VSS.n1166 VSS.n1165 8.18217
R7834 VSS.n1187 VSS.n1186 8.18217
R7835 VSS.n1026 VSS.n867 8.11757
R7836 VSS.n834 VSS.n822 8.11757
R7837 VSS.n1033 VSS.n1032 8.11757
R7838 VSS.n1107 VSS.n826 8.11757
R7839 VSS.n1649 VSS.n1647 8.11757
R7840 VSS.n1667 VSS.n1621 8.11757
R7841 VSS.n1907 VSS.n462 8.11757
R7842 VSS.n1882 VSS.n486 8.11757
R7843 VSS.n1522 VSS.n1196 7.96148
R7844 VSS.n1963 VSS.n419 7.94533
R7845 VSS.n419 VSS.n418 7.94533
R7846 VSS.n2022 VSS.n2021 7.94533
R7847 VSS.n2021 VSS.n397 7.94533
R7848 VSS.n2075 VSS.n375 7.94533
R7849 VSS.n375 VSS.n374 7.94533
R7850 VSS.n288 VSS.n287 7.94533
R7851 VSS.n287 VSS.n55 7.94533
R7852 VSS.n242 VSS.n97 7.94533
R7853 VSS.n242 VSS.n241 7.94533
R7854 VSS.n199 VSS.n198 7.94533
R7855 VSS.n198 VSS.n151 7.94533
R7856 VSS.n1854 VSS.n1853 7.50395
R7857 VSS.n1853 VSS.n512 7.50395
R7858 VSS.n1806 VSS.n551 7.50395
R7859 VSS.n1806 VSS.n1805 7.50395
R7860 VSS.n594 VSS.n593 7.50395
R7861 VSS.n1755 VSS.n594 7.50395
R7862 VSS.n1710 VSS.n1709 7.50395
R7863 VSS.n1709 VSS.n633 7.50395
R7864 VSS.n1356 VSS.n1355 7.50395
R7865 VSS.n1357 VSS.n1356 7.50395
R7866 VSS.n1289 VSS.n1274 7.50395
R7867 VSS.n1415 VSS.n1274 7.50395
R7868 VSS.n1491 VSS.n1490 7.50395
R7869 VSS.n1492 VSS.n1491 7.50395
R7870 VSS.n1317 VSS.n664 7.50395
R7871 VSS.n1609 VSS.n664 7.50395
R7872 VSS.n1405 VSS.n1279 7.50395
R7873 VSS.n1411 VSS.n1279 7.50395
R7874 VSS.n1530 VSS.n751 7.50395
R7875 VSS.n1530 VSS.n1529 7.50395
R7876 VSS.n1043 VSS.n1042 7.49318
R7877 VSS.n1102 VSS.n1101 7.49318
R7878 VSS.n1038 VSS.n874 7.49318
R7879 VSS.n1108 VSS.n1106 7.49318
R7880 VSS.n1651 VSS.n1650 7.49318
R7881 VSS.n1668 VSS.n1666 7.49318
R7882 VSS.n1904 VSS.n1903 7.49318
R7883 VSS.n1886 VSS.n1885 7.49318
R7884 VSS.n1865 VSS.n503 7.06257
R7885 VSS.n1699 VSS.n1698 7.06257
R7886 VSS.n935 VSS.n932 7.06257
R7887 VSS.n956 VSS.n924 7.06257
R7888 VSS.n1964 VSS.n1963 7.06257
R7889 VSS.n1970 VSS.n418 7.06257
R7890 VSS.n2022 VSS.n2020 7.06257
R7891 VSS.n2027 VSS.n397 7.06257
R7892 VSS.n2076 VSS.n2075 7.06257
R7893 VSS.n2082 VSS.n374 7.06257
R7894 VSS.n288 VSS.n52 7.06257
R7895 VSS.n57 VSS.n55 7.06257
R7896 VSS.n97 VSS.n95 7.06257
R7897 VSS.n241 VSS.n98 7.06257
R7898 VSS.n199 VSS.n148 7.06257
R7899 VSS.n153 VSS.n151 7.06257
R7900 VSS.n869 VSS.n868 6.86879
R7901 VSS.n846 VSS.n833 6.86879
R7902 VSS.n1037 VSS.n875 6.86879
R7903 VSS.n852 VSS.n829 6.86879
R7904 VSS.n1652 VSS.n1626 6.86879
R7905 VSS.n1665 VSS.n1664 6.86879
R7906 VSS.n472 VSS.n465 6.86879
R7907 VSS.n485 VSS.n484 6.86879
R7908 VSS.n511 VSS.n510 6.62119
R7909 VSS.n1850 VSS.n1849 6.62119
R7910 VSS.n1810 VSS.n1809 6.62119
R7911 VSS.n558 VSS.n554 6.62119
R7912 VSS.n1761 VSS.n589 6.62119
R7913 VSS.n1754 VSS.n595 6.62119
R7914 VSS.n632 VSS.n631 6.62119
R7915 VSS.n1706 VSS.n1705 6.62119
R7916 VSS.n1354 VSS.n1301 6.62119
R7917 VSS.n1358 VSS.n1299 6.62119
R7918 VSS.n1400 VSS.n1399 6.62119
R7919 VSS.n1417 VSS.n1416 6.62119
R7920 VSS.n1488 VSS.n1214 6.62119
R7921 VSS.n1494 VSS.n1493 6.62119
R7922 VSS.n1318 VSS.n658 6.62119
R7923 VSS.n1608 VSS.n665 6.62119
R7924 VSS.n1406 VSS.n1404 6.62119
R7925 VSS.n1410 VSS.n1280 6.62119
R7926 VSS.n1534 VSS.n1533 6.62119
R7927 VSS.n1197 VSS.n754 6.62119
R7928 VSS.n1064 VSS.n857 6.2444
R7929 VSS.n1079 VSS.n847 6.2444
R7930 VSS.n1068 VSS.n854 6.2444
R7931 VSS.n1075 VSS.n1074 6.2444
R7932 VSS.n1656 VSS.n1655 6.2444
R7933 VSS.n1663 VSS.n1624 6.2444
R7934 VSS.n1897 VSS.n473 6.2444
R7935 VSS.n1892 VSS.n477 6.2444
R7936 VSS.n1958 VSS.n421 6.17981
R7937 VSS.n1972 VSS.n1971 6.17981
R7938 VSS.n400 VSS.n399 6.17981
R7939 VSS.n2026 VSS.n395 6.17981
R7940 VSS.n2070 VSS.n377 6.17981
R7941 VSS.n2084 VSS.n2083 6.17981
R7942 VSS.n292 VSS.n291 6.17981
R7943 VSS.n282 VSS.n59 6.17981
R7944 VSS.n247 VSS.n93 6.17981
R7945 VSS.n238 VSS.n237 6.17981
R7946 VSS.n203 VSS.n202 6.17981
R7947 VSS.n193 VSS.n155 6.17981
R7948 VSS.n1194 VSS.n763 6.06897
R7949 VSS.n1161 VSS.n784 6.06897
R7950 VSS.n1860 VSS.n505 5.73843
R7951 VSS.n519 VSS.n515 5.73843
R7952 VSS.n550 VSS.n549 5.73843
R7953 VSS.n1799 VSS.n559 5.73843
R7954 VSS.n1762 VSS.n586 5.73843
R7955 VSS.n1751 VSS.n1750 5.73843
R7956 VSS.n1716 VSS.n627 5.73843
R7957 VSS.n640 VSS.n636 5.73843
R7958 VSS.n1362 VSS.n1361 5.73843
R7959 VSS.n1394 VSS.n1288 5.73843
R7960 VSS.n1422 VSS.n1271 5.73843
R7961 VSS.n1485 VSS.n1484 5.73843
R7962 VSS.n1605 VSS.n1604 5.73843
R7963 VSS.n1284 VSS.n1282 5.73843
R7964 VSS.n1426 VSS.n1268 5.73843
R7965 VSS.n750 VSS.n749 5.73843
R7966 VSS.n1063 VSS.n845 5.62001
R7967 VSS.n1080 VSS.n845 5.62001
R7968 VSS.n1070 VSS.n1069 5.62001
R7969 VSS.n1069 VSS.n851 5.62001
R7970 VSS.n1659 VSS.n1657 5.62001
R7971 VSS.n1660 VSS.n1659 5.62001
R7972 VSS.n1896 VSS.n474 5.62001
R7973 VSS.n1893 VSS.n474 5.62001
R7974 VSS.n1424 VSS.t16 5.35504
R7975 VSS.n1959 VSS.n1957 5.29705
R7976 VSS.n1977 VSS.n416 5.29705
R7977 VSS.n2014 VSS.n2013 5.29705
R7978 VSS.n2033 VSS.n394 5.29705
R7979 VSS.n2071 VSS.n2069 5.29705
R7980 VSS.n2089 VSS.n372 5.29705
R7981 VSS.n51 VSS.n49 5.29705
R7982 VSS.n281 VSS.n60 5.29705
R7983 VSS.n248 VSS.n90 5.29705
R7984 VSS.n114 VSS.n112 5.29705
R7985 VSS.n147 VSS.n145 5.29705
R7986 VSS.n192 VSS.n156 5.29705
R7987 VSS.n1064 VSS.n1063 4.99562
R7988 VSS.n1080 VSS.n1079 4.99562
R7989 VSS.n1070 VSS.n1068 4.99562
R7990 VSS.n1075 VSS.n851 4.99562
R7991 VSS.n1657 VSS.n1656 4.99562
R7992 VSS.n1660 VSS.n1624 4.99562
R7993 VSS.n1897 VSS.n1896 4.99562
R7994 VSS.n1893 VSS.n1892 4.99562
R7995 VSS.n1861 VSS.n503 4.85567
R7996 VSS.n1843 VSS.n520 4.85567
R7997 VSS.n1816 VSS.n545 4.85567
R7998 VSS.n1798 VSS.n560 4.85567
R7999 VSS.n1766 VSS.n1765 4.85567
R8000 VSS.n602 VSS.n598 4.85567
R8001 VSS.n1717 VSS.n624 4.85567
R8002 VSS.n1699 VSS.n641 4.85567
R8003 VSS.n1364 VSS.n1363 4.85567
R8004 VSS.n1395 VSS.n1393 4.85567
R8005 VSS.n1421 VSS.n1272 4.85567
R8006 VSS.n1483 VSS.n1482 4.85567
R8007 VSS.n675 VSS.n668 4.85567
R8008 VSS.n1283 VSS.n703 4.85567
R8009 VSS.n1428 VSS.n1427 4.85567
R8010 VSS.n1540 VSS.n740 4.85567
R8011 VSS.n1445 VSS.t9 4.6411
R8012 VSS.n1351 VSS.n1301 4.63498
R8013 VSS.n1493 VSS.n1212 4.63498
R8014 VSS.n658 VSS.n655 4.63498
R8015 VSS.n988 VSS.n911 4.60576
R8016 VSS.n1153 VSS.n1152 4.60576
R8017 VSS.n347 VSS.n346 4.55293
R8018 VSS.n325 VSS.n19 4.55292
R8019 VSS.n326 VSS.n325 4.55275
R8020 VSS.n348 VSS.n347 4.55274
R8021 VSS.n318 VSS.n30 4.53997
R8022 VSS.n323 VSS.n322 4.53997
R8023 VSS.n1205 VSS.n1203 4.53997
R8024 VSS.n1508 VSS.n1507 4.53997
R8025 VSS.n71 VSS.n70 4.53997
R8026 VSS.n67 VSS.n64 4.53997
R8027 VSS.n109 VSS.n108 4.53997
R8028 VSS.n106 VSS.n105 4.53997
R8029 VSS.n141 VSS.n140 4.53997
R8030 VSS.n137 VSS.n134 4.53997
R8031 VSS.n2153 VSS.n2152 4.53997
R8032 VSS.n2156 VSS.n2155 4.53997
R8033 VSS.n1693 VSS.n647 4.52682
R8034 VSS.n1696 VSS.n1695 4.52682
R8035 VSS.n1255 VSS.n1251 4.52682
R8036 VSS.n1258 VSS.n1253 4.52682
R8037 VSS.n1561 VSS.n705 4.52682
R8038 VSS.n1563 VSS.n707 4.52682
R8039 VSS.n718 VSS.n717 4.52682
R8040 VSS.n723 VSS.n711 4.52682
R8041 VSS.n1337 VSS.n1310 4.52682
R8042 VSS.n1340 VSS.n1339 4.52682
R8043 VSS.n1546 VSS.n731 4.52682
R8044 VSS.n1551 VSS.n730 4.52682
R8045 VSS.n1257 VSS.n1256 4.5005
R8046 VSS.n1260 VSS.n1259 4.5005
R8047 VSS.n1560 VSS.n1559 4.5005
R8048 VSS.n1565 VSS.n1564 4.5005
R8049 VSS.n715 VSS.n710 4.5005
R8050 VSS.n725 VSS.n724 4.5005
R8051 VSS.n1313 VSS.n1308 4.5005
R8052 VSS.n1336 VSS.n1335 4.5005
R8053 VSS.n1544 VSS.n733 4.5005
R8054 VSS.n1553 VSS.n1552 4.5005
R8055 VSS.n1510 VSS.n1509 4.5005
R8056 VSS.n988 VSS.n987 4.5005
R8057 VSS.n982 VSS.n908 4.5005
R8058 VSS.n993 VSS.n992 4.5005
R8059 VSS.n910 VSS.n888 4.5005
R8060 VSS.n909 VSS.n891 4.5005
R8061 VSS.n889 VSS.n883 4.5005
R8062 VSS.n1020 VSS.n1019 4.5005
R8063 VSS.n1023 VSS.n1022 4.5005
R8064 VSS.n1021 VSS.n864 4.5005
R8065 VSS.n866 VSS.n859 4.5005
R8066 VSS.n1053 VSS.n1052 4.5005
R8067 VSS.n1060 VSS.n1059 4.5005
R8068 VSS.n1058 VSS.n843 4.5005
R8069 VSS.n1057 VSS.n844 4.5005
R8070 VSS.n1056 VSS.n1055 4.5005
R8071 VSS.n1091 VSS.n838 4.5005
R8072 VSS.n1094 VSS.n1093 4.5005
R8073 VSS.n1099 VSS.n1098 4.5005
R8074 VSS.n1097 VSS.n818 4.5005
R8075 VSS.n1096 VSS.n821 4.5005
R8076 VSS.n1095 VSS.n814 4.5005
R8077 VSS.n1130 VSS.n799 4.5005
R8078 VSS.n1152 VSS.n1151 4.5005
R8079 VSS.n69 VSS.n68 4.5005
R8080 VSS.n102 VSS.n101 4.5005
R8081 VSS.n139 VSS.n138 4.5005
R8082 VSS.n2 VSS.n0 4.5005
R8083 VSS.n1692 VSS.n1691 4.5005
R8084 VSS.n650 VSS.n645 4.5005
R8085 VSS.n319 VSS.n32 4.5005
R8086 VSS.n1522 VSS.n1521 4.41429
R8087 VSS.n424 VSS.n423 4.41429
R8088 VSS.n1976 VSS.n414 4.41429
R8089 VSS.n2008 VSS.n402 4.41429
R8090 VSS.n2035 VSS.n2034 4.41429
R8091 VSS.n380 VSS.n379 4.41429
R8092 VSS.n2088 VSS.n370 4.41429
R8093 VSS.n297 VSS.n47 4.41429
R8094 VSS.n73 VSS.n62 4.41429
R8095 VSS.n252 VSS.n251 4.41429
R8096 VSS.n232 VSS.n116 4.41429
R8097 VSS.n208 VSS.n143 4.41429
R8098 VSS.n189 VSS.n188 4.41429
R8099 VSS.n868 VSS.n857 4.37123
R8100 VSS.n847 VSS.n846 4.37123
R8101 VSS.n875 VSS.n854 4.37123
R8102 VSS.n1074 VSS.n852 4.37123
R8103 VSS.n1655 VSS.n1626 4.37123
R8104 VSS.n1664 VSS.n1663 4.37123
R8105 VSS.n473 VSS.n472 4.37123
R8106 VSS.n484 VSS.n477 4.37123
R8107 VSS.n1842 VSS.n521 3.97291
R8108 VSS.n1817 VSS.n542 3.97291
R8109 VSS.n1795 VSS.n1794 3.97291
R8110 VSS.n585 VSS.n584 3.97291
R8111 VSS.n1744 VSS.n603 3.97291
R8112 VSS.n1721 VSS.n1720 3.97291
R8113 VSS.n1365 VSS.n1296 3.97291
R8114 VSS.n1391 VSS.n1390 3.97291
R8115 VSS.n1437 VSS.n1245 3.97291
R8116 VSS.n1481 VSS.n1216 3.97291
R8117 VSS.n1598 VSS.n676 3.97291
R8118 VSS.n1575 VSS.n1574 3.97291
R8119 VSS.n1433 VSS.n1249 3.97291
R8120 VSS.n1541 VSS.n739 3.97291
R8121 VSS.n1042 VSS.n869 3.74684
R8122 VSS.n1102 VSS.n833 3.74684
R8123 VSS.n1038 VSS.n1037 3.74684
R8124 VSS.n1106 VSS.n829 3.74684
R8125 VSS.n1652 VSS.n1651 3.74684
R8126 VSS.n1666 VSS.n1665 3.74684
R8127 VSS.n1903 VSS.n465 3.74684
R8128 VSS.n1886 VSS.n485 3.74684
R8129 VSS.n1186 VSS.n1185 3.53153
R8130 VSS.n1166 VSS.n788 3.53153
R8131 VSS.n1951 VSS.n1950 3.53153
R8132 VSS.n1983 VSS.n413 3.53153
R8133 VSS.n2009 VSS.n2007 3.53153
R8134 VSS.n2040 VSS.n392 3.53153
R8135 VSS.n2063 VSS.n2062 3.53153
R8136 VSS.n2095 VSS.n369 3.53153
R8137 VSS.n298 VSS.n45 3.53153
R8138 VSS.n277 VSS.n276 3.53153
R8139 VSS.n89 VSS.n87 3.53153
R8140 VSS.n231 VSS.n117 3.53153
R8141 VSS.n209 VSS.n132 3.53153
R8142 VSS.n161 VSS.n159 3.53153
R8143 VSS.n1258 VSS.n728 3.43045
R8144 VSS.n1563 VSS.n1562 3.43045
R8145 VSS.n711 VSS.n709 3.43045
R8146 VSS.n1338 VSS.n1337 3.43045
R8147 VSS.n1694 VSS.n1693 3.43045
R8148 VSS.n1695 VSS.n1694 3.42945
R8149 VSS.n1339 VSS.n1338 3.42945
R8150 VSS.n1255 VSS.n728 3.42945
R8151 VSS.n1562 VSS.n1561 3.42945
R8152 VSS.n717 VSS.n709 3.42945
R8153 VSS.n1555 VSS.n730 3.42905
R8154 VSS.n1555 VSS.n731 3.42905
R8155 VSS.n324 VSS.n30 3.42287
R8156 VSS.n70 VSS.n31 3.42287
R8157 VSS.n108 VSS.n107 3.42287
R8158 VSS.n140 VSS.n3 3.42287
R8159 VSS.n2154 VSS.n2153 3.42287
R8160 VSS.n1508 VSS.n732 3.41297
R8161 VSS.n1311 VSS.n1309 3.4105
R8162 VSS.n1556 VSS.n729 3.4105
R8163 VSS.n1557 VSS.n708 3.4105
R8164 VSS.n727 VSS.n726 3.4105
R8165 VSS.n1205 VSS.n732 3.4105
R8166 VSS.n648 VSS.n646 3.4105
R8167 VSS.n1555 VSS.n1554 3.4105
R8168 VSS.n134 VSS.n3 3.4105
R8169 VSS.n107 VSS.n106 3.4105
R8170 VSS.n64 VSS.n31 3.4105
R8171 VSS.n324 VSS.n323 3.4105
R8172 VSS.n990 VSS.n989 3.4105
R8173 VSS.n991 VSS.n990 3.4105
R8174 VSS.n2155 VSS.n2154 3.4105
R8175 VSS.n1602 VSS.t6 3.21322
R8176 VSS.n1043 VSS.n867 3.12245
R8177 VSS.n1101 VSS.n834 3.12245
R8178 VSS.n1032 VSS.n874 3.12245
R8179 VSS.n1108 VSS.n1107 3.12245
R8180 VSS.n1650 VSS.n1649 3.12245
R8181 VSS.n1668 VSS.n1667 3.12245
R8182 VSS.n1904 VSS.n462 3.12245
R8183 VSS.n1885 VSS.n486 3.12245
R8184 VSS.n1839 VSS.n1838 3.09016
R8185 VSS.n1821 VSS.n1820 3.09016
R8186 VSS.n568 VSS.n563 3.09016
R8187 VSS.n1772 VSS.n580 3.09016
R8188 VSS.n1743 VSS.n604 3.09016
R8189 VSS.n623 VSS.n622 3.09016
R8190 VSS.n1370 VSS.n1368 3.09016
R8191 VSS.n1389 VSS.n1291 3.09016
R8192 VSS.n1438 VSS.n1243 3.09016
R8193 VSS.n1478 VSS.n1477 3.09016
R8194 VSS.n1597 VSS.n677 3.09016
R8195 VSS.n702 VSS.n701 3.09016
R8196 VSS.n1432 VSS.n1250 3.09016
R8197 VSS.n1473 VSS.n1472 3.09016
R8198 VSS.n937 VSS.n935 2.64878
R8199 VSS.n956 VSS.n955 2.64878
R8200 VSS.n772 VSS.n770 2.64878
R8201 VSS.n1170 VSS.n1169 2.64878
R8202 VSS.n1930 VSS.n1929 2.64878
R8203 VSS.n1945 VSS.n426 2.64878
R8204 VSS.n1984 VSS.n411 2.64878
R8205 VSS.n405 VSS.n404 2.64878
R8206 VSS.n2039 VSS.n390 2.64878
R8207 VSS.n2057 VSS.n382 2.64878
R8208 VSS.n2096 VSS.n367 2.64878
R8209 VSS.n2116 VSS.n2115 2.64878
R8210 VSS.n36 VSS.n35 2.64878
R8211 VSS.n302 VSS.n301 2.64878
R8212 VSS.n272 VSS.n74 2.64878
R8213 VSS.n257 VSS.n85 2.64878
R8214 VSS.n228 VSS.n227 2.64878
R8215 VSS.n213 VSS.n212 2.64878
R8216 VSS.n183 VSS.n163 2.64878
R8217 VSS.n2148 VSS.n8 2.64878
R8218 VSS.n962 VSS.n960 2.49806
R8219 VSS.n1027 VSS.n1026 2.49806
R8220 VSS.n1117 VSS.n822 2.49806
R8221 VSS.n1165 VSS.n1164 2.49806
R8222 VSS.n966 VSS.n920 2.49806
R8223 VSS.n1033 VSS.n1031 2.49806
R8224 VSS.n1113 VSS.n826 2.49806
R8225 VSS.n1187 VSS.n767 2.49806
R8226 VSS.n2147 VSS.n2146 2.49806
R8227 VSS.n2121 VSS.n2120 2.49806
R8228 VSS.n1647 VSS.n1628 2.49806
R8229 VSS.n1683 VSS.n1621 2.49806
R8230 VSS.n2142 VSS.n16 2.49806
R8231 VSS.n440 VSS.n439 2.49806
R8232 VSS.n1908 VSS.n1907 2.49806
R8233 VSS.n1882 VSS.n1881 2.49806
R8234 VSS.n528 VSS.n524 2.2074
R8235 VSS.n541 VSS.n540 2.2074
R8236 VSS.n1788 VSS.n569 2.2074
R8237 VSS.n1773 VSS.n578 2.2074
R8238 VSS.n1740 VSS.n1739 2.2074
R8239 VSS.n1727 VSS.n616 2.2074
R8240 VSS.n1372 VSS.n1371 2.2074
R8241 VSS.n1386 VSS.n1385 2.2074
R8242 VSS.n1443 VSS.n1441 2.2074
R8243 VSS.n1230 VSS.n1218 2.2074
R8244 VSS.n1594 VSS.n1593 2.2074
R8245 VSS.n1581 VSS.n693 2.2074
R8246 VSS.n1447 VSS.n1239 2.2074
R8247 VSS.n1471 VSS.n1223 2.2074
R8248 VSS.n1321 VSS.n1316 2.18587
R8249 VSS.n1350 VSS.n1349 2.18587
R8250 VSS.n1200 VSS.n1196 2.18587
R8251 VSS.n1500 VSS.n1498 2.18587
R8252 VSS.n1616 VSS.n654 2.14231
R8253 VSS.n1525 VSS.n1524 2.14231
R8254 VSS.n961 VSS.n913 1.87367
R8255 VSS.n893 VSS.n881 1.87367
R8256 VSS.n1119 VSS.n1118 1.87367
R8257 VSS.n797 VSS.n792 1.87367
R8258 VSS.n967 VSS.n918 1.87367
R8259 VSS.n899 VSS.n877 1.87367
R8260 VSS.n1112 VSS.n827 1.87367
R8261 VSS.n1191 VSS.n1190 1.87367
R8262 VSS.n341 VSS.n9 1.87367
R8263 VSS.n355 VSS.n335 1.87367
R8264 VSS.n1644 VSS.n1643 1.87367
R8265 VSS.n1682 VSS.n1622 1.87367
R8266 VSS.n2141 VSS.n17 1.87367
R8267 VSS.n438 VSS.n437 1.87367
R8268 VSS.n461 VSS.n460 1.87367
R8269 VSS.n495 VSS.n489 1.87367
R8270 VSS.n1878 VSS.n493 1.78535
R8271 VSS.n1685 VSS.n638 1.78535
R8272 VSS.n325 VSS.n324 1.76746
R8273 VSS.n936 VSS.n931 1.76602
R8274 VSS.n927 VSS.n926 1.76602
R8275 VSS.n778 VSS.n777 1.76602
R8276 VSS.n787 VSS.n786 1.76602
R8277 VSS.n1934 VSS.n433 1.76602
R8278 VSS.n1946 VSS.n1944 1.76602
R8279 VSS.n1989 VSS.n1987 1.76602
R8280 VSS.n2001 VSS.n2000 1.76602
R8281 VSS.n2046 VSS.n389 1.76602
R8282 VSS.n2058 VSS.n2056 1.76602
R8283 VSS.n2101 VSS.n2099 1.76602
R8284 VSS.n2111 VSS.n361 1.76602
R8285 VSS.n316 VSS.n315 1.76602
R8286 VSS.n306 VSS.n41 1.76602
R8287 VSS.n271 VSS.n78 1.76602
R8288 VSS.n258 VSS.n83 1.76602
R8289 VSS.n122 VSS.n120 1.76602
R8290 VSS.n217 VSS.n128 1.76602
R8291 VSS.n182 VSS.n164 1.76602
R8292 VSS.n171 VSS.n6 1.76602
R8293 VSS.n347 VSS.n4 1.68968
R8294 VSS.n990 VSS.n4 1.68451
R8295 VSS.n1326 VSS.n1324 1.56148
R8296 VSS.n1304 VSS.n1303 1.56148
R8297 VSS.n1517 VSS.n1516 1.56148
R8298 VSS.n1504 VSS.n1501 1.56148
R8299 VSS.n2120 VSS.n336 1.56148
R8300 VSS.n440 VSS.n435 1.56148
R8301 VSS.n1832 VSS.n529 1.32464
R8302 VSS.n1827 VSS.n534 1.32464
R8303 VSS.n1787 VSS.n570 1.32464
R8304 VSS.n1777 VSS.n1776 1.32464
R8305 VSS.n611 VSS.n607 1.32464
R8306 VSS.n1728 VSS.n613 1.32464
R8307 VSS.n1373 VSS.n1294 1.32464
R8308 VSS.n1384 VSS.n1383 1.32464
R8309 VSS.n1442 VSS.n1232 1.32464
R8310 VSS.n1463 VSS.n1462 1.32464
R8311 VSS.n688 VSS.n681 1.32464
R8312 VSS.n1582 VSS.n690 1.32464
R8313 VSS.n1448 VSS.n1237 1.32464
R8314 VSS.n1468 VSS.n1467 1.32464
R8315 VSS.n977 VSS.n976 1.24928
R8316 VSS.n1009 VSS.n894 1.24928
R8317 VSS.n1133 VSS.n813 1.24928
R8318 VSS.n1158 VSS.n1157 1.24928
R8319 VSS.n972 VSS.n970 1.24928
R8320 VSS.n1005 VSS.n1004 1.24928
R8321 VSS.n1137 VSS.n809 1.24928
R8322 VSS.n1141 VSS.n766 1.24928
R8323 VSS.n344 VSS.n343 1.24928
R8324 VSS.n356 VSS.n354 1.24928
R8325 VSS.n1634 VSS.n1633 1.24928
R8326 VSS.n1642 VSS.n1641 1.24928
R8327 VSS.n1679 VSS.n1678 1.24928
R8328 VSS.n1688 VSS.n642 1.24928
R8329 VSS.n2138 VSS.n2137 1.24928
R8330 VSS.n2127 VSS.n328 1.24928
R8331 VSS.n1925 VSS.n1924 1.24928
R8332 VSS.n1914 VSS.n453 1.24928
R8333 VSS.n1876 VSS.n496 1.24928
R8334 VSS.n1868 VSS.n501 1.24928
R8335 VSS.n1579 VSS.t20 1.07141
R8336 VSS.n1325 VSS.n1314 0.937085
R8337 VSS.n1344 VSS.n1343 0.937085
R8338 VSS.n1513 VSS.n1201 0.937085
R8339 VSS.n1505 VSS.n1211 0.937085
R8340 VSS.n944 VSS.n943 0.883259
R8341 VSS.n949 VSS.n948 0.883259
R8342 VSS.n1178 VSS.n775 0.883259
R8343 VSS.n1176 VSS.n782 0.883259
R8344 VSS.n1935 VSS.n431 0.883259
R8345 VSS.n429 VSS.n428 0.883259
R8346 VSS.n1988 VSS.n409 0.883259
R8347 VSS.n1995 VSS.n407 0.883259
R8348 VSS.n2047 VSS.n387 0.883259
R8349 VSS.n385 VSS.n384 0.883259
R8350 VSS.n2100 VSS.n365 0.883259
R8351 VSS.n2110 VSS.n363 0.883259
R8352 VSS.n311 VSS.n37 0.883259
R8353 VSS.n307 VSS.n39 0.883259
R8354 VSS.n268 VSS.n267 0.883259
R8355 VSS.n262 VSS.n261 0.883259
R8356 VSS.n222 VSS.n124 0.883259
R8357 VSS.n218 VSS.n125 0.883259
R8358 VSS.n179 VSS.n178 0.883259
R8359 VSS.n173 VSS.n172 0.883259
R8360 VSS.n1911 VSS.t14 0.847305
R8361 VSS.t2 VSS.n1780 0.714438
R8362 VSS.n914 VSS.n906 0.62489
R8363 VSS.n1010 VSS.n892 0.62489
R8364 VSS.n1132 VSS.n801 0.62489
R8365 VSS.n802 VSS.n796 0.62489
R8366 VSS.n971 VSS.n901 0.62489
R8367 VSS.n902 VSS.n898 0.62489
R8368 VSS.n1138 VSS.n807 0.62489
R8369 VSS.n1144 VSS.n1143 0.62489
R8370 VSS.n342 VSS.n338 0.62489
R8371 VSS.n353 VSS.n352 0.62489
R8372 VSS.n1636 VSS.n1635 0.62489
R8373 VSS.n1640 VSS.n1631 0.62489
R8374 VSS.n1675 VSS.n1672 0.62489
R8375 VSS.n1689 VSS.n651 0.62489
R8376 VSS.n27 VSS.n20 0.62489
R8377 VSS.n2128 VSS.n28 0.62489
R8378 VSS.n450 VSS.n443 0.62489
R8379 VSS.n1915 VSS.n451 0.62489
R8380 VSS.n1875 VSS.n497 0.62489
R8381 VSS.n1871 VSS.n1869 0.62489
R8382 VSS.n107 VSS.n3 0.4705
R8383 VSS.n107 VSS.n31 0.46956
R8384 VSS.n324 VSS.n31 0.46204
R8385 VSS.n2154 VSS.n3 0.4611
R8386 VSS.n1831 VSS.n530 0.441879
R8387 VSS.n1828 VSS.n533 0.441879
R8388 VSS.n1784 VSS.n1783 0.441879
R8389 VSS.n577 VSS.n573 0.441879
R8390 VSS.n1733 VSS.n612 0.441879
R8391 VSS.n1732 VSS.n1731 0.441879
R8392 VSS.n1378 VSS.n1377 0.441879
R8393 VSS.n1379 VSS.n1293 0.441879
R8394 VSS.n1458 VSS.n1457 0.441879
R8395 VSS.n1233 VSS.n1229 0.441879
R8396 VSS.n1587 VSS.n689 0.441879
R8397 VSS.n1586 VSS.n1585 0.441879
R8398 VSS.n1453 VSS.n1451 0.441879
R8399 VSS.n1452 VSS.n1225 0.441879
R8400 VSS.n1430 VSS.n1266 0.401268
R8401 VSS.n1573 VSS.n1571 0.401268
R8402 VSS.n719 VSS.n679 0.401268
R8403 VSS.n1547 VSS.n1543 0.401268
R8404 VSS.n1537 VSS.t4 0.357469
R8405 VSS.n279 VSS.n71 0.349294
R8406 VSS.n110 VSS.n109 0.349294
R8407 VSS.n142 VSS.n141 0.349294
R8408 VSS.n2152 VSS.n2150 0.349294
R8409 VSS.n318 VSS.n317 0.349294
R8410 VSS.n1333 VSS.n1332 0.312695
R8411 VSS.n1315 VSS.n1306 0.312695
R8412 VSS.n1512 VSS.n1202 0.312695
R8413 VSS.n1210 VSS.n1209 0.312695
R8414 VSS.n1557 VSS.n727 0.2825
R8415 VSS.n1557 VSS.n1556 0.2825
R8416 VSS.n1556 VSS.n1555 0.2825
R8417 VSS.n1309 VSS.n727 0.23268
R8418 VSS.n1555 VSS.n732 0.22704
R8419 VSS.n1862 VSS.n504 0.155672
R8420 VSS.n513 VSS.n504 0.155672
R8421 VSS.n1852 VSS.n513 0.155672
R8422 VSS.n1852 VSS.n1851 0.155672
R8423 VSS.n1851 VSS.n514 0.155672
R8424 VSS.n522 VSS.n514 0.155672
R8425 VSS.n1841 VSS.n522 0.155672
R8426 VSS.n1841 VSS.n1840 0.155672
R8427 VSS.n1840 VSS.n523 0.155672
R8428 VSS.n531 VSS.n523 0.155672
R8429 VSS.n1830 VSS.n531 0.155672
R8430 VSS.n1830 VSS.n1829 0.155672
R8431 VSS.n1829 VSS.n532 0.155672
R8432 VSS.n543 VSS.n532 0.155672
R8433 VSS.n1819 VSS.n543 0.155672
R8434 VSS.n1819 VSS.n1818 0.155672
R8435 VSS.n1818 VSS.n544 0.155672
R8436 VSS.n552 VSS.n544 0.155672
R8437 VSS.n1808 VSS.n552 0.155672
R8438 VSS.n1808 VSS.n1807 0.155672
R8439 VSS.n1807 VSS.n553 0.155672
R8440 VSS.n561 VSS.n553 0.155672
R8441 VSS.n1797 VSS.n561 0.155672
R8442 VSS.n1797 VSS.n1796 0.155672
R8443 VSS.n1796 VSS.n562 0.155672
R8444 VSS.n571 VSS.n562 0.155672
R8445 VSS.n1786 VSS.n571 0.155672
R8446 VSS.n1786 VSS.n1785 0.155672
R8447 VSS.n1785 VSS.n572 0.155672
R8448 VSS.n1775 VSS.n572 0.155672
R8449 VSS.n1775 VSS.n1774 0.155672
R8450 VSS.n1774 VSS.n579 0.155672
R8451 VSS.n587 VSS.n579 0.155672
R8452 VSS.n1764 VSS.n587 0.155672
R8453 VSS.n1764 VSS.n1763 0.155672
R8454 VSS.n1763 VSS.n588 0.155672
R8455 VSS.n596 VSS.n588 0.155672
R8456 VSS.n1753 VSS.n596 0.155672
R8457 VSS.n1753 VSS.n1752 0.155672
R8458 VSS.n1752 VSS.n597 0.155672
R8459 VSS.n605 VSS.n597 0.155672
R8460 VSS.n1742 VSS.n605 0.155672
R8461 VSS.n1742 VSS.n1741 0.155672
R8462 VSS.n1741 VSS.n606 0.155672
R8463 VSS.n614 VSS.n606 0.155672
R8464 VSS.n1730 VSS.n614 0.155672
R8465 VSS.n1730 VSS.n1729 0.155672
R8466 VSS.n1729 VSS.n615 0.155672
R8467 VSS.n625 VSS.n615 0.155672
R8468 VSS.n1719 VSS.n625 0.155672
R8469 VSS.n1719 VSS.n1718 0.155672
R8470 VSS.n1718 VSS.n626 0.155672
R8471 VSS.n634 VSS.n626 0.155672
R8472 VSS.n1708 VSS.n634 0.155672
R8473 VSS.n1708 VSS.n1707 0.155672
R8474 VSS.n1707 VSS.n635 0.155672
R8475 VSS.n643 VSS.n635 0.155672
R8476 VSS.n1353 VSS.n1300 0.155672
R8477 VSS.n1359 VSS.n1300 0.155672
R8478 VSS.n1360 VSS.n1359 0.155672
R8479 VSS.n1360 VSS.n1297 0.155672
R8480 VSS.n1366 VSS.n1297 0.155672
R8481 VSS.n1367 VSS.n1366 0.155672
R8482 VSS.n1367 VSS.n1295 0.155672
R8483 VSS.n1374 VSS.n1295 0.155672
R8484 VSS.n1376 VSS.n1374 0.155672
R8485 VSS.n1376 VSS.n1375 0.155672
R8486 VSS.n1375 VSS.n1292 0.155672
R8487 VSS.n1387 VSS.n1292 0.155672
R8488 VSS.n1388 VSS.n1387 0.155672
R8489 VSS.n1388 VSS.n1290 0.155672
R8490 VSS.n1396 VSS.n1290 0.155672
R8491 VSS.n1397 VSS.n1396 0.155672
R8492 VSS.n1398 VSS.n1397 0.155672
R8493 VSS.n1398 VSS.n1273 0.155672
R8494 VSS.n1418 VSS.n1273 0.155672
R8495 VSS.n1419 VSS.n1418 0.155672
R8496 VSS.n1420 VSS.n1419 0.155672
R8497 VSS.n1420 VSS.n1244 0.155672
R8498 VSS.n1439 VSS.n1244 0.155672
R8499 VSS.n1440 VSS.n1439 0.155672
R8500 VSS.n1440 VSS.n1231 0.155672
R8501 VSS.n1459 VSS.n1231 0.155672
R8502 VSS.n1460 VSS.n1459 0.155672
R8503 VSS.n1461 VSS.n1460 0.155672
R8504 VSS.n1461 VSS.n1217 0.155672
R8505 VSS.n1479 VSS.n1217 0.155672
R8506 VSS.n1480 VSS.n1479 0.155672
R8507 VSS.n1480 VSS.n1215 0.155672
R8508 VSS.n1486 VSS.n1215 0.155672
R8509 VSS.n1487 VSS.n1486 0.155672
R8510 VSS.n1487 VSS.n1213 0.155672
R8511 VSS.n1495 VSS.n1213 0.155672
R8512 VSS.n1431 VSS.n1238 0.155672
R8513 VSS.n1449 VSS.n1238 0.155672
R8514 VSS.n1450 VSS.n1449 0.155672
R8515 VSS.n1450 VSS.n1224 0.155672
R8516 VSS.n1469 VSS.n1224 0.155672
R8517 VSS.n1470 VSS.n1469 0.155672
R8518 VSS.n1470 VSS.n737 0.155672
R8519 VSS.n1281 VSS.n704 0.155672
R8520 VSS.n1407 VSS.n1281 0.155672
R8521 VSS.n1408 VSS.n1407 0.155672
R8522 VSS.n1409 VSS.n1408 0.155672
R8523 VSS.n1409 VSS.n1267 0.155672
R8524 VSS.n1429 VSS.n1267 0.155672
R8525 VSS.n1596 VSS.n1595 0.155672
R8526 VSS.n1595 VSS.n680 0.155672
R8527 VSS.n691 VSS.n680 0.155672
R8528 VSS.n1584 VSS.n691 0.155672
R8529 VSS.n1584 VSS.n1583 0.155672
R8530 VSS.n1583 VSS.n692 0.155672
R8531 VSS.n1572 VSS.n692 0.155672
R8532 VSS.n1319 VSS.n666 0.155672
R8533 VSS.n1607 VSS.n666 0.155672
R8534 VSS.n1607 VSS.n1606 0.155672
R8535 VSS.n1606 VSS.n667 0.155672
R8536 VSS.n678 VSS.n667 0.155672
R8537 VSS.n1542 VSS.n738 0.155672
R8538 VSS.n752 VSS.n738 0.155672
R8539 VSS.n1532 VSS.n752 0.155672
R8540 VSS.n1532 VSS.n1531 0.155672
R8541 VSS.n1531 VSS.n753 0.155672
R8542 VSS.n1520 VSS.n753 0.155672
R8543 VSS.n934 VSS.n930 0.155672
R8544 VSS.n945 VSS.n930 0.155672
R8545 VSS.n946 VSS.n945 0.155672
R8546 VSS.n947 VSS.n946 0.155672
R8547 VSS.n947 VSS.n925 0.155672
R8548 VSS.n957 VSS.n925 0.155672
R8549 VSS.n776 VSS.n769 0.155672
R8550 VSS.n779 VSS.n776 0.155672
R8551 VSS.n780 VSS.n779 0.155672
R8552 VSS.n781 VSS.n780 0.155672
R8553 VSS.n789 VSS.n781 0.155672
R8554 VSS.n790 VSS.n789 0.155672
R8555 VSS.n1168 VSS.n1167 0.155672
R8556 VSS.n278 VSS.n72 0.155672
R8557 VSS.n270 VSS.n72 0.155672
R8558 VSS.n270 VSS.n269 0.155672
R8559 VSS.n269 VSS.n79 0.155672
R8560 VSS.n260 VSS.n79 0.155672
R8561 VSS.n260 VSS.n259 0.155672
R8562 VSS.n259 VSS.n84 0.155672
R8563 VSS.n91 VSS.n84 0.155672
R8564 VSS.n250 VSS.n91 0.155672
R8565 VSS.n250 VSS.n249 0.155672
R8566 VSS.n249 VSS.n92 0.155672
R8567 VSS.n99 VSS.n92 0.155672
R8568 VSS.n240 VSS.n239 0.155672
R8569 VSS.n239 VSS.n111 0.155672
R8570 VSS.n118 VSS.n111 0.155672
R8571 VSS.n230 VSS.n118 0.155672
R8572 VSS.n230 VSS.n229 0.155672
R8573 VSS.n229 VSS.n119 0.155672
R8574 VSS.n126 VSS.n119 0.155672
R8575 VSS.n220 VSS.n126 0.155672
R8576 VSS.n220 VSS.n219 0.155672
R8577 VSS.n219 VSS.n127 0.155672
R8578 VSS.n211 VSS.n127 0.155672
R8579 VSS.n211 VSS.n210 0.155672
R8580 VSS.n201 VSS.n149 0.155672
R8581 VSS.n201 VSS.n200 0.155672
R8582 VSS.n200 VSS.n150 0.155672
R8583 VSS.n157 VSS.n150 0.155672
R8584 VSS.n191 VSS.n157 0.155672
R8585 VSS.n191 VSS.n190 0.155672
R8586 VSS.n190 VSS.n158 0.155672
R8587 VSS.n165 VSS.n158 0.155672
R8588 VSS.n181 VSS.n165 0.155672
R8589 VSS.n181 VSS.n180 0.155672
R8590 VSS.n180 VSS.n166 0.155672
R8591 VSS.n166 VSS.n5 0.155672
R8592 VSS.n1928 VSS.n432 0.155672
R8593 VSS.n1936 VSS.n432 0.155672
R8594 VSS.n1937 VSS.n1936 0.155672
R8595 VSS.n1937 VSS.n427 0.155672
R8596 VSS.n1947 VSS.n427 0.155672
R8597 VSS.n1948 VSS.n1947 0.155672
R8598 VSS.n1949 VSS.n1948 0.155672
R8599 VSS.n1949 VSS.n422 0.155672
R8600 VSS.n1960 VSS.n422 0.155672
R8601 VSS.n1961 VSS.n1960 0.155672
R8602 VSS.n1962 VSS.n1961 0.155672
R8603 VSS.n1962 VSS.n417 0.155672
R8604 VSS.n1973 VSS.n417 0.155672
R8605 VSS.n1974 VSS.n1973 0.155672
R8606 VSS.n1975 VSS.n1974 0.155672
R8607 VSS.n1975 VSS.n412 0.155672
R8608 VSS.n1985 VSS.n412 0.155672
R8609 VSS.n1986 VSS.n1985 0.155672
R8610 VSS.n1986 VSS.n408 0.155672
R8611 VSS.n1997 VSS.n408 0.155672
R8612 VSS.n1998 VSS.n1997 0.155672
R8613 VSS.n1999 VSS.n1998 0.155672
R8614 VSS.n1999 VSS.n403 0.155672
R8615 VSS.n2010 VSS.n403 0.155672
R8616 VSS.n2011 VSS.n2010 0.155672
R8617 VSS.n2012 VSS.n2011 0.155672
R8618 VSS.n2012 VSS.n398 0.155672
R8619 VSS.n2023 VSS.n398 0.155672
R8620 VSS.n2024 VSS.n2023 0.155672
R8621 VSS.n2025 VSS.n2024 0.155672
R8622 VSS.n2025 VSS.n393 0.155672
R8623 VSS.n2036 VSS.n393 0.155672
R8624 VSS.n2037 VSS.n2036 0.155672
R8625 VSS.n2038 VSS.n2037 0.155672
R8626 VSS.n2038 VSS.n388 0.155672
R8627 VSS.n2048 VSS.n388 0.155672
R8628 VSS.n2049 VSS.n2048 0.155672
R8629 VSS.n2049 VSS.n383 0.155672
R8630 VSS.n2059 VSS.n383 0.155672
R8631 VSS.n2060 VSS.n2059 0.155672
R8632 VSS.n2061 VSS.n2060 0.155672
R8633 VSS.n2061 VSS.n378 0.155672
R8634 VSS.n2072 VSS.n378 0.155672
R8635 VSS.n2073 VSS.n2072 0.155672
R8636 VSS.n2074 VSS.n2073 0.155672
R8637 VSS.n2074 VSS.n373 0.155672
R8638 VSS.n2085 VSS.n373 0.155672
R8639 VSS.n2086 VSS.n2085 0.155672
R8640 VSS.n2087 VSS.n2086 0.155672
R8641 VSS.n2087 VSS.n368 0.155672
R8642 VSS.n2097 VSS.n368 0.155672
R8643 VSS.n2098 VSS.n2097 0.155672
R8644 VSS.n2098 VSS.n364 0.155672
R8645 VSS.n2108 VSS.n364 0.155672
R8646 VSS.n2109 VSS.n2108 0.155672
R8647 VSS.n2109 VSS.n360 0.155672
R8648 VSS.n2117 VSS.n360 0.155672
R8649 VSS.n309 VSS.n34 0.155672
R8650 VSS.n309 VSS.n308 0.155672
R8651 VSS.n308 VSS.n40 0.155672
R8652 VSS.n300 VSS.n40 0.155672
R8653 VSS.n300 VSS.n299 0.155672
R8654 VSS.n299 VSS.n46 0.155672
R8655 VSS.n53 VSS.n46 0.155672
R8656 VSS.n290 VSS.n53 0.155672
R8657 VSS.n290 VSS.n289 0.155672
R8658 VSS.n289 VSS.n54 0.155672
R8659 VSS.n61 VSS.n54 0.155672
R8660 VSS.n280 VSS.n61 0.155672
R8661 VSS.n210 VSS.n142 0.151362
R8662 VSS.n279 VSS.n278 0.147052
R8663 VSS.n2118 VSS.n359 0.134646
R8664 VSS.n1927 VSS.n1926 0.134646
R8665 VSS.n1864 VSS.n1863 0.134646
R8666 VSS.n2149 VSS.n7 0.132123
R8667 VSS.n33 VSS.n18 0.132123
R8668 VSS.n1430 VSS.n1429 0.127655
R8669 VSS VSS.n790 0.1255
R8670 VSS.n1322 VSS.n1320 0.122451
R8671 VSS.n1352 VSS.n1302 0.122451
R8672 VSS.n1497 VSS.n1496 0.122451
R8673 VSS.n959 VSS.n958 0.122451
R8674 VSS.n933 VSS.n919 0.122451
R8675 VSS.n1520 VSS.n1519 0.121347
R8676 VSS.n1864 VSS.n1862 0.116879
R8677 VSS.n1697 VSS.n643 0.116879
R8678 VSS.n1928 VSS.n1927 0.116879
R8679 VSS.n2118 VSS.n2117 0.116879
R8680 VSS.n1353 VSS.n1352 0.110414
R8681 VSS.n1496 VSS.n1495 0.110414
R8682 VSS.n1320 VSS.n1319 0.110414
R8683 VSS.n1323 VSS.n1322 0.110256
R8684 VSS.n1342 VSS.n1341 0.110256
R8685 VSS.n1341 VSS.n1302 0.110256
R8686 VSS.n1519 VSS.n1518 0.110256
R8687 VSS.n1518 VSS.n1198 0.110256
R8688 VSS.n1506 VSS.n1206 0.110256
R8689 VSS.n1497 VSS.n1206 0.110256
R8690 VSS.n968 VSS.n919 0.110256
R8691 VSS.n969 VSS.n968 0.110256
R8692 VSS.n969 VSS.n900 0.110256
R8693 VSS.n1001 VSS.n900 0.110256
R8694 VSS.n1002 VSS.n1001 0.110256
R8695 VSS.n1003 VSS.n1002 0.110256
R8696 VSS.n1003 VSS.n876 0.110256
R8697 VSS.n1034 VSS.n876 0.110256
R8698 VSS.n1035 VSS.n1034 0.110256
R8699 VSS.n1036 VSS.n1035 0.110256
R8700 VSS.n1036 VSS.n853 0.110256
R8701 VSS.n1071 VSS.n853 0.110256
R8702 VSS.n1072 VSS.n1071 0.110256
R8703 VSS.n1073 VSS.n1072 0.110256
R8704 VSS.n1073 VSS.n828 0.110256
R8705 VSS.n1109 VSS.n828 0.110256
R8706 VSS.n1110 VSS.n1109 0.110256
R8707 VSS.n1111 VSS.n1110 0.110256
R8708 VSS.n1111 VSS.n808 0.110256
R8709 VSS.n1139 VSS.n808 0.110256
R8710 VSS.n1140 VSS.n1139 0.110256
R8711 VSS.n1142 VSS.n1140 0.110256
R8712 VSS.n1142 VSS.n768 0.110256
R8713 VSS.n1189 VSS.n768 0.110256
R8714 VSS.n1189 VSS.n1188 0.110256
R8715 VSS.n1156 VSS.n1155 0.110256
R8716 VSS.n1155 VSS.n791 0.110256
R8717 VSS.n340 VSS.n7 0.110256
R8718 VSS.n345 VSS.n340 0.110256
R8719 VSS.n349 VSS.n337 0.110256
R8720 VSS.n357 VSS.n337 0.110256
R8721 VSS.n358 VSS.n357 0.110256
R8722 VSS.n2119 VSS.n358 0.110256
R8723 VSS.n1632 VSS.n359 0.110256
R8724 VSS.n1638 VSS.n1632 0.110256
R8725 VSS.n1639 VSS.n1638 0.110256
R8726 VSS.n1639 VSS.n1629 0.110256
R8727 VSS.n1645 VSS.n1629 0.110256
R8728 VSS.n1646 VSS.n1645 0.110256
R8729 VSS.n1646 VSS.n1627 0.110256
R8730 VSS.n1653 VSS.n1627 0.110256
R8731 VSS.n1654 VSS.n1653 0.110256
R8732 VSS.n1654 VSS.n1625 0.110256
R8733 VSS.n1661 VSS.n1625 0.110256
R8734 VSS.n1662 VSS.n1661 0.110256
R8735 VSS.n1662 VSS.n1623 0.110256
R8736 VSS.n1669 VSS.n1623 0.110256
R8737 VSS.n1670 VSS.n1669 0.110256
R8738 VSS.n1681 VSS.n1670 0.110256
R8739 VSS.n1681 VSS.n1680 0.110256
R8740 VSS.n1680 VSS.n1671 0.110256
R8741 VSS.n2140 VSS.n18 0.110256
R8742 VSS.n2140 VSS.n2139 0.110256
R8743 VSS.n2130 VSS.n2129 0.110256
R8744 VSS.n2129 VSS.n327 0.110256
R8745 VSS.n436 VSS.n327 0.110256
R8746 VSS.n441 VSS.n436 0.110256
R8747 VSS.n1926 VSS.n442 0.110256
R8748 VSS.n1917 VSS.n442 0.110256
R8749 VSS.n1917 VSS.n1916 0.110256
R8750 VSS.n1916 VSS.n452 0.110256
R8751 VSS.n463 VSS.n452 0.110256
R8752 VSS.n1906 VSS.n463 0.110256
R8753 VSS.n1906 VSS.n1905 0.110256
R8754 VSS.n1905 VSS.n464 0.110256
R8755 VSS.n475 VSS.n464 0.110256
R8756 VSS.n1895 VSS.n475 0.110256
R8757 VSS.n1895 VSS.n1894 0.110256
R8758 VSS.n1894 VSS.n476 0.110256
R8759 VSS.n487 VSS.n476 0.110256
R8760 VSS.n1884 VSS.n487 0.110256
R8761 VSS.n1884 VSS.n1883 0.110256
R8762 VSS.n1883 VSS.n488 0.110256
R8763 VSS.n498 VSS.n488 0.110256
R8764 VSS.n1874 VSS.n498 0.110256
R8765 VSS.n1874 VSS.n1873 0.110256
R8766 VSS.n1873 VSS.n499 0.110256
R8767 VSS.n1863 VSS.n499 0.110256
R8768 VSS.n1697 VSS.n1696 0.108732
R8769 VSS.n1573 VSS.n704 0.106103
R8770 VSS.n1260 VSS.n1253 0.105763
R8771 VSS.n1565 VSS.n707 0.105763
R8772 VSS.n724 VSS.n723 0.105763
R8773 VSS.n1552 VSS.n1551 0.105763
R8774 VSS.n992 VSS.n908 0.105763
R8775 VSS.n910 VSS.n909 0.105763
R8776 VSS.n909 VSS.n883 0.105763
R8777 VSS.n1020 VSS.n883 0.105763
R8778 VSS.n1022 VSS.n1020 0.105763
R8779 VSS.n1022 VSS.n1021 0.105763
R8780 VSS.n1021 VSS.n859 0.105763
R8781 VSS.n1053 VSS.n859 0.105763
R8782 VSS.n1059 VSS.n1053 0.105763
R8783 VSS.n1059 VSS.n1058 0.105763
R8784 VSS.n1058 VSS.n1057 0.105763
R8785 VSS.n1057 VSS.n1056 0.105763
R8786 VSS.n1056 VSS.n838 0.105763
R8787 VSS.n1094 VSS.n838 0.105763
R8788 VSS.n1098 VSS.n1094 0.105763
R8789 VSS.n1098 VSS.n1097 0.105763
R8790 VSS.n1097 VSS.n1096 0.105763
R8791 VSS.n1096 VSS.n1095 0.105763
R8792 VSS.n1095 VSS.n799 0.105763
R8793 VSS.n1152 VSS.n799 0.105763
R8794 VSS.n1323 VSS.n1310 0.102634
R8795 VSS.n991 VSS.n910 0.102474
R8796 VSS.n71 VSS.n63 0.0958947
R8797 VSS.n109 VSS.n100 0.0958947
R8798 VSS.n141 VSS.n133 0.0958947
R8799 VSS.n2152 VSS.n2151 0.0958947
R8800 VSS.n320 VSS.n318 0.0958947
R8801 VSS.n2150 VSS.n5 0.0910172
R8802 VSS.n2150 VSS.n2149 0.0910172
R8803 VSS.n317 VSS.n33 0.0910172
R8804 VSS.n317 VSS.n34 0.0910172
R8805 VSS.n1335 VSS.n1312 0.090439
R8806 VSS.n1261 VSS 0.0893158
R8807 VSS.n1566 VSS 0.0893158
R8808 VSS VSS.n734 0.0893158
R8809 VSS.n105 VSS 0.087671
R8810 VSS VSS.n2156 0.087671
R8811 VSS.n346 VSS.n345 0.0843415
R8812 VSS.n2139 VSS.n19 0.0843415
R8813 VSS.n1309 VSS.n646 0.08416
R8814 VSS.n1156 VSS.n1154 0.0832782
R8815 VSS.n1254 VSS.n1251 0.0827368
R8816 VSS.n1558 VSS.n705 0.0827368
R8817 VSS.n718 VSS.n716 0.0827368
R8818 VSS.n1546 VSS.n1545 0.0827368
R8819 VSS.n989 VSS.n988 0.0827368
R8820 VSS.n1188 VSS.n769 0.0803991
R8821 VSS.n1167 VSS.n791 0.0803991
R8822 VSS.n1693 VSS.n1692 0.0794474
R8823 VSS.n1695 VSS.n645 0.0794474
R8824 VSS.n1256 VSS.n1255 0.0794474
R8825 VSS.n1259 VSS.n1258 0.0794474
R8826 VSS.n1561 VSS.n1560 0.0794474
R8827 VSS.n1564 VSS.n1563 0.0794474
R8828 VSS.n717 VSS.n710 0.0794474
R8829 VSS.n725 VSS.n711 0.0794474
R8830 VSS.n1337 VSS.n1336 0.0794474
R8831 VSS.n1339 VSS.n1308 0.0794474
R8832 VSS.n733 VSS.n731 0.0794474
R8833 VSS.n1553 VSS.n730 0.0794474
R8834 VSS.n2154 VSS.n4 0.07852
R8835 VSS.n1334 VSS.n1313 0.0782439
R8836 VSS.n1573 VSS.n1572 0.075931
R8837 VSS.n1507 VSS.n1506 0.0721463
R8838 VSS.n348 VSS.n339 0.0721463
R8839 VSS.n650 VSS.n644 0.0721463
R8840 VSS.n326 VSS.n29 0.0721463
R8841 VSS.n715 VSS 0.069579
R8842 VSS.n934 VSS.n933 0.0694655
R8843 VSS.n958 VSS.n957 0.0694655
R8844 VSS.n32 VSS.n30 0.0662895
R8845 VSS.n323 VSS.n32 0.0662895
R8846 VSS.n1509 VSS.n1205 0.0662895
R8847 VSS.n1509 VSS.n1508 0.0662895
R8848 VSS.n70 VSS.n69 0.0662895
R8849 VSS.n69 VSS.n64 0.0662895
R8850 VSS.n108 VSS.n101 0.0662895
R8851 VSS.n106 VSS.n101 0.0662895
R8852 VSS.n140 VSS.n139 0.0662895
R8853 VSS.n139 VSS.n134 0.0662895
R8854 VSS.n2153 VSS.n2 0.0662895
R8855 VSS.n2155 VSS.n2 0.0662895
R8856 VSS.n1340 VSS.n1307 0.0660488
R8857 VSS.n1203 VSS.n1198 0.063
R8858 VSS.n1671 VSS.n647 0.063
R8859 VSS.n1510 VSS.n1204 0.0599512
R8860 VSS.n1691 VSS.n1690 0.0599512
R8861 VSS.n68 VSS 0.0564211
R8862 VSS VSS.n137 0.0564211
R8863 VSS.n1431 VSS.n1430 0.0543793
R8864 VSS.n1692 VSS.n648 0.0531316
R8865 VSS.n648 VSS.n645 0.0531316
R8866 VSS.n1256 VSS.n729 0.0531316
R8867 VSS.n1259 VSS.n729 0.0531316
R8868 VSS.n1560 VSS.n708 0.0531316
R8869 VSS.n1564 VSS.n708 0.0531316
R8870 VSS.n726 VSS.n710 0.0531316
R8871 VSS.n726 VSS.n725 0.0531316
R8872 VSS.n1336 VSS.n1311 0.0531316
R8873 VSS.n1311 VSS.n1308 0.0531316
R8874 VSS.n1554 VSS.n733 0.0531316
R8875 VSS.n1554 VSS.n1553 0.0531316
R8876 VSS.n319 VSS 0.0531316
R8877 VSS.n322 VSS 0.0531316
R8878 VSS.n1511 VSS.n1510 0.0508049
R8879 VSS.n1691 VSS.n649 0.0508049
R8880 VSS VSS.n67 0.0498421
R8881 VSS.n138 VSS 0.0498421
R8882 VSS.n1511 VSS.n1203 0.0477561
R8883 VSS.n649 VSS.n647 0.0477561
R8884 VSS.n1342 VSS.n1340 0.0447073
R8885 VSS.n1507 VSS.n1204 0.0386098
R8886 VSS.n349 VSS.n348 0.0386098
R8887 VSS.n1690 VSS.n650 0.0386098
R8888 VSS.n2130 VSS.n326 0.0386098
R8889 VSS.n1266 VSS.n1251 0.0366842
R8890 VSS.n1571 VSS.n705 0.0366842
R8891 VSS.n719 VSS.n718 0.0366842
R8892 VSS.n1547 VSS.n1546 0.0366842
R8893 VSS.n959 VSS.n911 0.0360734
R8894 VSS.n280 VSS.n279 0.0349828
R8895 VSS.n1313 VSS.n1307 0.0325122
R8896 VSS.n1168 VSS 0.0306724
R8897 VSS.n149 VSS.n142 0.0306724
R8898 VSS.n1018 VSS.n884 0.0293866
R8899 VSS.n1090 VSS.n839 0.0293866
R8900 VSS.n891 VSS.n890 0.0278109
R8901 VSS.n1054 VSS.n844 0.0278109
R8902 VSS.n1151 VSS.n798 0.0278109
R8903 VSS.n1023 VSS.n882 0.0272857
R8904 VSS.n1093 VSS.n1092 0.0272857
R8905 VSS VSS.n712 0.0268158
R8906 VSS.n346 VSS.n339 0.0264146
R8907 VSS.n1696 VSS.n644 0.0264146
R8908 VSS.n29 VSS.n19 0.0264146
R8909 VSS.n1543 VSS.n737 0.0242069
R8910 VSS.n679 VSS.n678 0.0242069
R8911 VSS.n1012 VSS.n888 0.0236092
R8912 VSS.n1082 VSS.n843 0.0236092
R8913 VSS.n1130 VSS.n800 0.0236092
R8914 VSS.n1257 VSS.n1254 0.0235263
R8915 VSS.n1559 VSS.n1558 0.0235263
R8916 VSS.n716 VSS.n715 0.0235263
R8917 VSS.n1545 VSS.n1544 0.0235263
R8918 VSS.n989 VSS.n908 0.0235263
R8919 VSS.n1025 VSS.n864 0.023084
R8920 VSS.n1100 VSS.n1099 0.023084
R8921 VSS.n1335 VSS.n1334 0.0203171
R8922 VSS.n994 VSS.n993 0.0194076
R8923 VSS.n1061 VSS.n1060 0.0194076
R8924 VSS.n1129 VSS.n814 0.0194076
R8925 VSS.n987 VSS.n912 0.0188824
R8926 VSS.n1044 VSS.n866 0.0188824
R8927 VSS.n836 VSS.n818 0.0188824
R8928 VSS VSS.n102 0.0185921
R8929 VSS VSS.n0 0.0185921
R8930 VSS.n2119 VSS.n2118 0.0157439
R8931 VSS.n1927 VSS.n441 0.0157439
R8932 VSS.n983 VSS.n982 0.0152059
R8933 VSS.n1052 VSS.n1051 0.0152059
R8934 VSS.n821 VSS.n820 0.0152059
R8935 VSS.n982 VSS.n978 0.0146807
R8936 VSS.n1052 VSS.n860 0.0146807
R8937 VSS.n1120 VSS.n821 0.0146807
R8938 VSS.n110 VSS.n99 0.013431
R8939 VSS.n240 VSS.n110 0.013431
R8940 VSS.n987 VSS.n986 0.0110042
R8941 VSS.n866 VSS.n865 0.0110042
R8942 VSS.n1121 VSS.n818 0.0110042
R8943 VSS.n993 VSS.n907 0.010479
R8944 VSS.n1060 VSS.n858 0.010479
R8945 VSS.n819 VSS.n814 0.010479
R8946 VSS.n1261 VSS.n1260 0.0103684
R8947 VSS.n1566 VSS.n1565 0.0103684
R8948 VSS.n724 VSS.n712 0.0103684
R8949 VSS.n1552 VSS.n734 0.0103684
R8950 VSS.n68 VSS.n63 0.0103684
R8951 VSS.n102 VSS.n100 0.0103684
R8952 VSS.n138 VSS.n133 0.0103684
R8953 VSS.n2151 VSS.n0 0.0103684
R8954 VSS.n320 VSS.n319 0.0103684
R8955 VSS.n979 VSS.n912 0.00942857
R8956 VSS.n986 VSS.n978 0.00942857
R8957 VSS.n983 VSS.n907 0.00942857
R8958 VSS.n995 VSS.n994 0.00942857
R8959 VSS.n1012 VSS.n1011 0.00942857
R8960 VSS.n1025 VSS.n1024 0.00942857
R8961 VSS.n1045 VSS.n1044 0.00942857
R8962 VSS.n865 VSS.n860 0.00942857
R8963 VSS.n1051 VSS.n858 0.00942857
R8964 VSS.n1062 VSS.n1061 0.00942857
R8965 VSS.n1082 VSS.n1081 0.00942857
R8966 VSS.n1100 VSS.n835 0.00942857
R8967 VSS.n837 VSS.n836 0.00942857
R8968 VSS.n1121 VSS.n1120 0.00942857
R8969 VSS.n820 VSS.n819 0.00942857
R8970 VSS.n1131 VSS.n1129 0.00942857
R8971 VSS.n1150 VSS.n800 0.00942857
R8972 VSS.n1312 VSS.n1310 0.00812195
R8973 VSS.n1019 VSS.n882 0.00732773
R8974 VSS.n1092 VSS.n1091 0.00732773
R8975 VSS VSS.n1257 0.00707895
R8976 VSS.n1559 VSS 0.00707895
R8977 VSS.n1544 VSS 0.00707895
R8978 VSS.n979 VSS.n911 0.00680252
R8979 VSS.n890 VSS.n889 0.00680252
R8980 VSS.n1045 VSS.n864 0.00680252
R8981 VSS.n1055 VSS.n1054 0.00680252
R8982 VSS.n1099 VSS.n837 0.00680252
R8983 VSS.n1153 VSS.n798 0.00680252
R8984 VSS.n995 VSS.n888 0.00627731
R8985 VSS.n1062 VSS.n843 0.00627731
R8986 VSS.n1131 VSS.n1130 0.00627731
R8987 VSS.n992 VSS.n991 0.00378947
R8988 VSS.n889 VSS.n884 0.00312605
R8989 VSS.n1055 VSS.n839 0.00312605
R8990 VSS.n1154 VSS.n1153 0.00312605
R8991 VSS.n1596 VSS.n679 0.00265517
R8992 VSS.n1543 VSS.n1542 0.00265517
R8993 VSS.n1019 VSS.n1018 0.00260084
R8994 VSS.n1024 VSS.n1023 0.00260084
R8995 VSS.n1091 VSS.n1090 0.00260084
R8996 VSS.n1093 VSS.n835 0.00260084
R8997 VSS.n1011 VSS.n891 0.00207563
R8998 VSS.n1081 VSS.n844 0.00207563
R8999 VSS.n1151 VSS 0.00155042
R9000 VSS.n1694 VSS.n646 0.00103455
R9001 VSS.n1338 VSS.n1309 0.00103455
R9002 VSS.n1556 VSS.n728 0.00103455
R9003 VSS.n1562 VSS.n1557 0.00103455
R9004 VSS.n727 VSS.n709 0.00103455
R9005 VSS VSS.n1150 0.00102521
R9006 vgp.n0 vgp.n1 585
R9007 vgp.n3 vgp.n2 13.2471
R9008 vgp.n0 vgp.n3 285.877
R9009 vgp.n6 vgp.n5 13.2471
R9010 vgp.n0 vgp.n6 285.877
R9011 vgp.n9 vgp.n8 13.2471
R9012 vgp.n0 vgp.n9 285.877
R9013 vgp.n12 vgp.n11 13.2471
R9014 vgp.n0 vgp.n12 285.877
R9015 vgp.n15 vgp.n14 13.2471
R9016 vgp.n0 vgp.n15 285.877
R9017 vgp.n18 vgp.n17 13.2471
R9018 vgp.n0 vgp.n18 285.877
R9019 vgp.n21 vgp.n20 13.2471
R9020 vgp.n0 vgp.n21 285.877
R9021 vgp.n24 vgp.n23 13.2471
R9022 vgp.n24 vgp.n0 285.877
R9023 vgp.n0 vgp.t1 7.8805
R9024 vgp.n0 vgp.t3 7.8805
R9025 vgp.n25 vgp.n1 9.3005
R9026 vgp.n26 vgp.n2 9.3005
R9027 vgp.n27 vgp.n4 9.3005
R9028 vgp.n28 vgp.n5 9.3005
R9029 vgp.n29 vgp.n7 9.3005
R9030 vgp.n30 vgp.n8 9.3005
R9031 vgp.n31 vgp.n10 9.3005
R9032 vgp.n32 vgp.n11 9.3005
R9033 vgp.n33 vgp.n13 9.3005
R9034 vgp.n34 vgp.n14 9.3005
R9035 vgp.n35 vgp.n16 9.3005
R9036 vgp.n36 vgp.n17 9.3005
R9037 vgp.n37 vgp.n19 9.3005
R9038 vgp.n38 vgp.n20 9.3005
R9039 vgp.n39 vgp.n22 9.3005
R9040 vgp.n40 vgp.n23 9.3005
R9041 vgp.n41 vgp.n24 22.5471
R9042 vgp.n1 vgp.n2 27.1064
R9043 vgp.n4 vgp.n3 13.2471
R9044 vgp.n4 vgp.n5 27.1064
R9045 vgp.n7 vgp.n6 13.2471
R9046 vgp.n7 vgp.n8 27.1064
R9047 vgp.n10 vgp.n9 13.2471
R9048 vgp.n10 vgp.n11 27.1064
R9049 vgp.n13 vgp.n12 13.2471
R9050 vgp.n13 vgp.n14 27.1064
R9051 vgp.n16 vgp.n15 13.2471
R9052 vgp.n16 vgp.n17 27.1064
R9053 vgp.n19 vgp.n18 13.2471
R9054 vgp.n19 vgp.n20 27.1064
R9055 vgp.n22 vgp.n21 13.2471
R9056 vgp.n22 vgp.n23 27.1064
R9057 vgp.n25 vgp.n42 4.5005
R9058 vgp.n44 vgp.n45 4.5005
R9059 vgp.n46 vgp.n47 4.5005
R9060 vgp.n48 vgp.n49 4.5005
R9061 vgp.n50 vgp.n51 4.5005
R9062 vgp.n52 vgp.n53 4.5005
R9063 vgp.n54 vgp.n55 4.5005
R9064 vgp.n56 vgp.n57 4.5005
R9065 vgp.n33 vgp.n58 4.5005
R9066 vgp.n59 vgp.n60 4.5005
R9067 vgp.n61 vgp.n62 4.5005
R9068 vgp.n63 vgp.n64 4.5005
R9069 vgp.n65 vgp.n66 4.5005
R9070 vgp.n67 vgp.n68 4.5005
R9071 vgp.n69 vgp.n70 4.5005
R9072 vgp.n71 vgp.n72 4.5005
R9073 vgp.n73 vgp.n181 4.5005
R9074 vgp.n73 vgp.n25 0.1255
R9075 vgp.n26 vgp.n73 0.016125
R9076 vgp.n71 vgp.n26 0.109875
R9077 vgp.n27 vgp.n71 0.03175
R9078 vgp.n69 vgp.n27 0.09425
R9079 vgp.n28 vgp.n69 0.047375
R9080 vgp.n67 vgp.n28 0.078625
R9081 vgp.n29 vgp.n67 0.063
R9082 vgp.n65 vgp.n29 0.063
R9083 vgp.n30 vgp.n65 0.078625
R9084 vgp.n63 vgp.n30 0.047375
R9085 vgp.n31 vgp.n63 0.09425
R9086 vgp.n61 vgp.n31 0.03175
R9087 vgp.n32 vgp.n61 0.109875
R9088 vgp.n59 vgp.n32 0.016125
R9089 vgp.n33 vgp.n59 0.1255
R9090 vgp.n56 vgp.n33 0.1255
R9091 vgp.n34 vgp.n56 0.016125
R9092 vgp.n54 vgp.n34 0.109875
R9093 vgp.n35 vgp.n54 0.03175
R9094 vgp.n52 vgp.n35 0.09425
R9095 vgp.n36 vgp.n52 0.047375
R9096 vgp.n50 vgp.n36 0.078625
R9097 vgp.n37 vgp.n50 0.063
R9098 vgp.n48 vgp.n37 0.063
R9099 vgp.n38 vgp.n48 0.078625
R9100 vgp.n46 vgp.n38 0.047375
R9101 vgp.n39 vgp.n46 0.09425
R9102 vgp.n44 vgp.n39 0.03175
R9103 vgp.n40 vgp.n44 0.109875
R9104 vgp.n43 vgp.n40 0.0774358
R9105 vgp.n41 vgp.n43 0.0635
R9106 vgp.n330 vgp.n41 0.198286
R9107 vgp.n184 vgp.n183 9.3005
R9108 vgp.n186 vgp.n185 9.3005
R9109 vgp.n191 vgp.n190 9.3005
R9110 vgp.n192 vgp 9.3005
R9111 vgp.n197 vgp.n196 9.3005
R9112 vgp.n199 vgp.n198 9.3005
R9113 vgp.n204 vgp.n203 9.3005
R9114 vgp.n206 vgp.n205 9.3005
R9115 vgp.n211 vgp.n210 9.3005
R9116 vgp.n212 vgp.n213 9.3005
R9117 vgp.n218 vgp.n217 9.3005
R9118 vgp.n219 vgp.n220 9.3005
R9119 vgp.n225 vgp.n224 9.3005
R9120 vgp.n226 vgp.n227 9.3005
R9121 vgp.n232 vgp.n231 9.3005
R9122 vgp.n233 vgp.n234 9.3005
R9123 vgp.n239 vgp.n238 9.3005
R9124 vgp.n241 vgp.n240 9.3005
R9125 vgp.n246 vgp.n247 9.3005
R9126 vgp.n249 vgp.n248 9.3005
R9127 vgp.n251 vgp.n250 9.3005
R9128 vgp.n258 vgp.n257 9.3005
R9129 vgp.n259 vgp.n260 9.3005
R9130 vgp.n262 vgp.n261 9.3005
R9131 vgp.n269 vgp.n268 9.3005
R9132 vgp.n270 vgp.n271 9.3005
R9133 vgp.n273 vgp.n272 9.3005
R9134 vgp.n280 vgp.n279 9.3005
R9135 vgp.n281 vgp.n282 9.3005
R9136 vgp.n284 vgp.n283 9.3005
R9137 vgp.n291 vgp.n290 9.3005
R9138 vgp.n293 vgp.n292 9.3005
R9139 vgp.n295 vgp.n294 9.3005
R9140 vgp.n302 vgp.n301 9.3005
R9141 vgp.n304 vgp.n303 9.3005
R9142 vgp.n305 vgp.n306 9.3005
R9143 vgp.n313 vgp.n312 9.3005
R9144 vgp.n314 vgp.n315 9.3005
R9145 vgp.n317 vgp.n316 9.3005
R9146 vgp vgp.n322 16.4265
R9147 vgp.n324 vgp.n323 9.3005
R9148 vgp.n326 vgp.n325 9.3005
R9149 vgp.n330 vgp.n182 0.228148
R9150 vgp.n189 vgp.n330 0.163
R9151 vgp.n189 vgp 0.0755
R9152 vgp vgp.n186 0.0755
R9153 vgp.n184 vgp.n186 0.1505
R9154 vgp.n195 vgp.n184 0.854667
R9155 vgp.n195 vgp 0.1505
R9156 vgp vgp.n191 0.1505
R9157 vgp.n202 vgp.n191 0.3255
R9158 vgp.n202 vgp 0.0796667
R9159 vgp vgp.n199 0.0713333
R9160 vgp.n197 vgp.n199 0.1505
R9161 vgp.n209 vgp.n197 0.3255
R9162 vgp.n209 vgp 0.115083
R9163 vgp vgp.n206 0.0359167
R9164 vgp.n204 vgp.n206 0.1505
R9165 vgp.n216 vgp.n204 0.3255
R9166 vgp.n213 vgp.n216 0.1505
R9167 vgp.n213 vgp 0.0359167
R9168 vgp vgp.n211 0.115083
R9169 vgp.n223 vgp.n211 0.3255
R9170 vgp.n220 vgp.n223 0.1505
R9171 vgp.n220 vgp 0.0359167
R9172 vgp vgp.n218 0.115083
R9173 vgp.n230 vgp.n218 0.3255
R9174 vgp.n227 vgp.n230 0.1505
R9175 vgp.n227 vgp 0.115083
R9176 vgp vgp.n225 0.0359167
R9177 vgp.n237 vgp.n225 0.3255
R9178 vgp.n234 vgp.n237 0.1505
R9179 vgp.n234 vgp 0.0671667
R9180 vgp vgp.n232 0.0838333
R9181 vgp.n244 vgp.n232 0.3255
R9182 vgp.n244 vgp 0.0359167
R9183 vgp vgp.n241 0.115083
R9184 vgp.n239 vgp.n241 0.1505
R9185 vgp.n255 vgp.n239 1.45883
R9186 vgp.n251 vgp.n255 0.1505
R9187 vgp.n249 vgp.n251 0.1505
R9188 vgp.n247 vgp.n249 0.1505
R9189 vgp.n247 vgp 0.0213333
R9190 vgp vgp.n245 0.129667
R9191 vgp.n266 vgp.n245 0.442167
R9192 vgp.n262 vgp.n266 0.1505
R9193 vgp.n260 vgp.n262 0.1505
R9194 vgp.n260 vgp 0.115083
R9195 vgp vgp.n258 0.0359167
R9196 vgp.n256 vgp.n258 0.1505
R9197 vgp.n277 vgp.n256 0.442167
R9198 vgp.n273 vgp.n277 0.1505
R9199 vgp.n271 vgp.n273 0.1505
R9200 vgp.n271 vgp 0.129667
R9201 vgp vgp.n269 0.0213333
R9202 vgp.n267 vgp.n269 0.1505
R9203 vgp.n288 vgp.n267 0.442167
R9204 vgp.n284 vgp.n288 0.1505
R9205 vgp.n282 vgp.n284 0.1505
R9206 vgp.n282 vgp 0.0359167
R9207 vgp vgp.n280 0.115083
R9208 vgp.n278 vgp.n280 0.1505
R9209 vgp.n299 vgp.n278 0.442167
R9210 vgp.n299 vgp 0.063
R9211 vgp vgp.n295 0.088
R9212 vgp.n293 vgp.n295 0.1505
R9213 vgp.n291 vgp.n293 0.1505
R9214 vgp.n289 vgp.n291 0.1505
R9215 vgp.n310 vgp.n289 0.442167
R9216 vgp.n306 vgp.n310 0.1505
R9217 vgp.n306 vgp 0.115083
R9218 vgp vgp.n304 0.0359167
R9219 vgp.n302 vgp.n304 0.1505
R9220 vgp.n300 vgp.n302 0.1505
R9221 vgp.n321 vgp.n300 0.442167
R9222 vgp.n317 vgp.n321 0.1505
R9223 vgp.n315 vgp.n317 0.1505
R9224 vgp.n315 vgp 0.115083
R9225 vgp vgp.n313 0.0359167
R9226 vgp.n311 vgp.n313 0.1505
R9227 vgp.n329 vgp.n311 0.442167
R9228 vgp.n326 vgp.n329 0.1505
R9229 vgp.n324 vgp.n326 0.1505
R9230 vgp vgp.n324 0.1505
R9231 vgp.n322 vgp.n323 15.0817
R9232 vgp.n325 vgp.n328 11.3247
R9233 vgp.n329 vgp.n328 23.0638
R9234 vgp.n325 vgp.n323 27.1064
R9235 vgp.n322 vgp.n327 59.2396
R9236 vgp.n328 vgp.n327 109.918
R9237 vgp.n327 vgp.t5 75.313
R9238 vgp.n312 vgp.n318 11.3247
R9239 vgp.n319 vgp.n314 152
R9240 vgp.n316 vgp.n320 11.3247
R9241 vgp.n321 vgp.n320 23.0638
R9242 vgp.n316 vgp.n314 27.1064
R9243 vgp.n312 vgp.n314 27.1064
R9244 vgp.n318 vgp.n311 23.0638
R9245 vgp.n320 vgp.n319 109.918
R9246 vgp.n318 vgp.n319 109.918
R9247 vgp.n319 vgp.t6 75.313
R9248 vgp.n301 vgp.n307 11.3247
R9249 vgp.n308 vgp.n303 152
R9250 vgp.n305 vgp.n309 11.3247
R9251 vgp.n310 vgp.n309 23.0638
R9252 vgp.n303 vgp.n305 27.1064
R9253 vgp.n303 vgp.n301 27.1064
R9254 vgp.n307 vgp.n300 23.0638
R9255 vgp.n309 vgp.n308 109.918
R9256 vgp.n307 vgp.n308 109.918
R9257 vgp.n308 vgp.t7 75.313
R9258 vgp.n290 vgp.n296 11.3247
R9259 vgp.n297 vgp.n292 152
R9260 vgp.n294 vgp.n298 11.3247
R9261 vgp.n298 vgp.n299 23.0638
R9262 vgp.n294 vgp.n292 27.1064
R9263 vgp.n292 vgp.n290 27.1064
R9264 vgp.n296 vgp.n289 23.0638
R9265 vgp.n298 vgp.n297 109.918
R9266 vgp.n296 vgp.n297 109.918
R9267 vgp.n297 vgp.t8 75.313
R9268 vgp.n279 vgp.n285 11.3247
R9269 vgp.n286 vgp.n281 152
R9270 vgp.n283 vgp.n287 11.3247
R9271 vgp.n288 vgp.n287 23.0638
R9272 vgp.n283 vgp.n281 27.1064
R9273 vgp.n279 vgp.n281 27.1064
R9274 vgp.n285 vgp.n278 23.0638
R9275 vgp.n287 vgp.n286 109.918
R9276 vgp.n285 vgp.n286 109.918
R9277 vgp.n286 vgp.t9 75.313
R9278 vgp.n268 vgp.n274 11.3247
R9279 vgp.n275 vgp.n270 152
R9280 vgp.n272 vgp.n276 11.3247
R9281 vgp.n277 vgp.n276 23.0638
R9282 vgp.n272 vgp.n270 27.1064
R9283 vgp.n268 vgp.n270 27.1064
R9284 vgp.n274 vgp.n267 23.0638
R9285 vgp.n276 vgp.n275 109.918
R9286 vgp.n274 vgp.n275 109.918
R9287 vgp.n275 vgp.t10 75.313
R9288 vgp.n257 vgp.n263 11.3247
R9289 vgp.n264 vgp.n259 152
R9290 vgp.n261 vgp.n265 11.3247
R9291 vgp.n266 vgp.n265 23.0638
R9292 vgp.n261 vgp.n259 27.1064
R9293 vgp.n257 vgp.n259 27.1064
R9294 vgp.n263 vgp.n256 23.0638
R9295 vgp.n265 vgp.n264 109.918
R9296 vgp.n263 vgp.n264 109.918
R9297 vgp.n264 vgp.t11 75.313
R9298 vgp.n252 vgp.n246 11.3247
R9299 vgp.n253 vgp.n248 152
R9300 vgp.n250 vgp.n254 11.3247
R9301 vgp.n255 vgp.n254 23.0638
R9302 vgp.n250 vgp.n248 27.1064
R9303 vgp.n248 vgp.n246 27.1064
R9304 vgp.n245 vgp.n252 23.0638
R9305 vgp.n254 vgp.n253 109.918
R9306 vgp.n252 vgp.n253 109.918
R9307 vgp.n253 vgp.t12 75.313
R9308 vgp.n240 vgp.n242 11.3247
R9309 vgp.n242 vgp.n244 23.0638
R9310 vgp.n240 vgp.n238 27.1064
R9311 vgp.n242 vgp.n243 77.1778
R9312 vgp.n243 vgp.n238 184.74
R9313 vgp.n243 vgp.t13 150.625
R9314 vgp.n233 vgp.n235 11.3247
R9315 vgp.n237 vgp.n235 23.0638
R9316 vgp.n231 vgp.n233 27.1064
R9317 vgp.n235 vgp.n236 77.1778
R9318 vgp.n236 vgp.n231 184.74
R9319 vgp.n236 vgp.t14 150.625
R9320 vgp.n226 vgp.n228 11.3247
R9321 vgp.n230 vgp.n228 23.0638
R9322 vgp.n224 vgp.n226 27.1064
R9323 vgp.n228 vgp.n229 77.1778
R9324 vgp.n229 vgp.n224 184.74
R9325 vgp.n229 vgp.t15 150.625
R9326 vgp.n219 vgp.n221 11.3247
R9327 vgp.n223 vgp.n221 23.0638
R9328 vgp.n217 vgp.n219 27.1064
R9329 vgp.n221 vgp.n222 77.1778
R9330 vgp.n222 vgp.n217 184.74
R9331 vgp.n222 vgp.t16 150.625
R9332 vgp.n212 vgp.n214 11.3247
R9333 vgp.n216 vgp.n214 23.0638
R9334 vgp.n210 vgp.n212 27.1064
R9335 vgp.n214 vgp.n215 77.1778
R9336 vgp.n215 vgp.n210 184.74
R9337 vgp.n215 vgp.t17 150.625
R9338 vgp.n205 vgp.n207 11.3247
R9339 vgp.n207 vgp.n209 23.0638
R9340 vgp.n205 vgp.n203 27.1064
R9341 vgp.n207 vgp.n208 77.1778
R9342 vgp.n208 vgp.n203 184.74
R9343 vgp.n208 vgp.t18 150.625
R9344 vgp.n198 vgp.n200 11.3247
R9345 vgp.n200 vgp.n202 23.0638
R9346 vgp.n198 vgp.n196 27.1064
R9347 vgp.n200 vgp.n201 77.1778
R9348 vgp.n201 vgp.n196 184.74
R9349 vgp.n201 vgp.t19 150.625
R9350 vgp.n192 vgp.n193 11.3247
R9351 vgp.n193 vgp.n195 23.0638
R9352 vgp.n190 vgp.n192 27.1064
R9353 vgp.n193 vgp.n194 77.1778
R9354 vgp.n194 vgp.n190 184.74
R9355 vgp.n194 vgp.t20 150.625
R9356 vgp.n185 vgp.n187 11.3247
R9357 vgp.n187 vgp.n189 23.0638
R9358 vgp.n185 vgp.n183 27.1064
R9359 vgp.n187 vgp.n188 77.1778
R9360 vgp.n188 vgp.n183 184.74
R9361 vgp.n188 vgp.t2 150.625
R9362 vgp.n182 vgp 0.0319608
R9363 vgp.n182 vgp.t0 211.214
R9364 vgp.n181 vgp.n42 0.1255
R9365 vgp.n72 vgp.n181 0.1255
R9366 vgp.n70 vgp.n72 0.1255
R9367 vgp.n68 vgp.n70 0.1255
R9368 vgp.n66 vgp.n68 0.1255
R9369 vgp.n64 vgp.n66 0.1255
R9370 vgp.n62 vgp.n64 0.1255
R9371 vgp.n60 vgp.n62 0.1255
R9372 vgp.n58 vgp.n60 0.1255
R9373 vgp.n57 vgp.n58 0.1255
R9374 vgp.n55 vgp.n57 0.1255
R9375 vgp.n53 vgp.n55 0.1255
R9376 vgp.n51 vgp.n53 0.1255
R9377 vgp.n49 vgp.n51 0.1255
R9378 vgp.n47 vgp.n49 0.1255
R9379 vgp.n45 vgp.n47 0.1255
R9380 vgp.n43 vgp.n45 2.376
R9381 vgp.n76 vgp.n77 4.5005
R9382 vgp.n79 vgp.n78 4.5005
R9383 vgp.n80 vgp.n81 4.5005
R9384 vgp.n82 vgp.n83 4.5005
R9385 vgp.n84 vgp.n85 4.5005
R9386 vgp.n86 vgp.n87 4.5005
R9387 vgp.n88 vgp.n89 4.5005
R9388 vgp.n90 vgp.n91 4.5005
R9389 vgp.n92 vgp.n93 4.5005
R9390 vgp.n94 vgp.n95 4.5005
R9391 vgp.n96 vgp.n97 4.5005
R9392 vgp.n98 vgp.n99 4.5005
R9393 vgp.n100 vgp.n101 4.5005
R9394 vgp.n102 vgp.n103 4.5005
R9395 vgp.n104 vgp.n105 4.5005
R9396 vgp.n106 vgp.n107 4.5005
R9397 vgp.n108 vgp.n109 4.5005
R9398 vgp.n110 vgp.n111 4.5005
R9399 vgp.n112 vgp.n113 4.5005
R9400 vgp.n114 vgp.n115 4.5005
R9401 vgp.n116 vgp.n117 4.5005
R9402 vgp.n118 vgp.n119 4.5005
R9403 vgp.n119 vgp.n74 2.3874
R9404 vgp.n117 vgp.n119 0.1255
R9405 vgp.n115 vgp.n117 0.1255
R9406 vgp.n113 vgp.n115 0.1255
R9407 vgp.n111 vgp.n113 0.1255
R9408 vgp.n109 vgp.n111 0.1255
R9409 vgp.n107 vgp.n109 0.1255
R9410 vgp.n105 vgp.n107 0.1255
R9411 vgp.n103 vgp.n105 0.1255
R9412 vgp.n101 vgp.n103 0.1255
R9413 vgp.n99 vgp.n101 0.1255
R9414 vgp.n97 vgp.n99 0.1255
R9415 vgp.n95 vgp.n97 0.1255
R9416 vgp.n93 vgp.n95 0.1255
R9417 vgp.n91 vgp.n93 0.1255
R9418 vgp.n89 vgp.n91 0.1255
R9419 vgp.n87 vgp.n89 0.1255
R9420 vgp.n85 vgp.n87 0.1255
R9421 vgp.n83 vgp.n85 0.1255
R9422 vgp.n81 vgp.n83 0.1255
R9423 vgp.n79 vgp.n81 0.1255
R9424 vgp.n77 vgp.n79 0.1255
R9425 vgp.n75 vgp.n77 0.1255
R9426 vgp.n42 vgp.n75 1.02537
R9427 vgp.n121 vgp.n120 9.3005
R9428 vgp.n123 vgp.n122 9.3005
R9429 vgp.n125 vgp.n124 9.3005
R9430 vgp.n127 vgp.n126 9.3005
R9431 vgp.n129 vgp.n128 9.3005
R9432 vgp.n131 vgp.n130 9.3005
R9433 vgp.n133 vgp.n132 9.3005
R9434 vgp.n135 vgp.n134 9.3005
R9435 vgp.n137 vgp.n136 9.3005
R9436 vgp.n139 vgp.n138 9.3005
R9437 vgp.n141 vgp.n140 9.3005
R9438 vgp.n143 vgp.n142 9.3005
R9439 vgp.n145 vgp.n144 9.3005
R9440 vgp.n147 vgp.n146 9.3005
R9441 vgp.n149 vgp.n148 9.3005
R9442 vgp.n151 vgp.n150 9.3005
R9443 vgp.n153 vgp.n152 9.3005
R9444 vgp.n155 vgp.n154 9.3005
R9445 vgp.n157 vgp.n156 9.3005
R9446 vgp.n159 vgp.n158 9.3005
R9447 vgp.n160 vgp.n74 25.8333
R9448 vgp.n74 vgp.n121 0.0894713
R9449 vgp.n121 vgp.n118 0.0864375
R9450 vgp.n118 vgp.n123 0.0551875
R9451 vgp.n123 vgp.n116 0.0708125
R9452 vgp.n116 vgp.n125 0.0708125
R9453 vgp.n125 vgp.n114 0.0551875
R9454 vgp.n114 vgp.n127 0.0864375
R9455 vgp.n127 vgp.n112 0.0395625
R9456 vgp.n112 vgp.n129 0.102062
R9457 vgp.n129 vgp.n110 0.0239375
R9458 vgp.n110 vgp.n131 0.117688
R9459 vgp.n131 vgp.n108 0.0083125
R9460 vgp.n108 vgp.n106 0.1255
R9461 vgp.n106 vgp.n133 0.0083125
R9462 vgp.n133 vgp.n104 0.117688
R9463 vgp.n104 vgp.n135 0.0239375
R9464 vgp.n135 vgp.n102 0.102062
R9465 vgp.n137 vgp.n102 0.0395625
R9466 vgp.n100 vgp.n137 0.0864375
R9467 vgp.n139 vgp.n100 0.0551875
R9468 vgp.n98 vgp.n139 0.0708125
R9469 vgp.n141 vgp.n98 0.0708125
R9470 vgp.n96 vgp.n141 0.0551875
R9471 vgp.n143 vgp.n96 0.0864375
R9472 vgp.n94 vgp.n143 0.0395625
R9473 vgp.n145 vgp.n94 0.102062
R9474 vgp.n92 vgp.n145 0.0239375
R9475 vgp.n147 vgp.n92 0.117688
R9476 vgp.n90 vgp.n147 0.0083125
R9477 vgp.n88 vgp.n90 0.1255
R9478 vgp.n149 vgp.n88 0.0083125
R9479 vgp.n86 vgp.n149 0.117688
R9480 vgp.n151 vgp.n86 0.0239375
R9481 vgp.n84 vgp.n151 0.102062
R9482 vgp.n153 vgp.n84 0.0395625
R9483 vgp.n82 vgp.n153 0.0864375
R9484 vgp.n155 vgp.n82 0.0551875
R9485 vgp.n80 vgp.n155 0.0708125
R9486 vgp.n157 vgp.n80 0.0708125
R9487 vgp.n78 vgp.n157 0.0551875
R9488 vgp.n78 vgp.n159 0.0864375
R9489 vgp.n159 vgp 0.0337031
R9490 vgp vgp.n76 0.00635938
R9491 vgp.n180 vgp.n76 0.102062
R9492 vgp.n75 vgp.n180 4.52394
R9493 vgp.n120 vgp.n160 9.2683
R9494 vgp.n122 vgp.n161 185
R9495 vgp.n124 vgp.n162 185
R9496 vgp.n126 vgp.n163 185
R9497 vgp.n128 vgp.n164 185
R9498 vgp.n130 vgp.n165 185
R9499 vgp.n132 vgp.n166 185
R9500 vgp.n134 vgp.n167 185
R9501 vgp.n136 vgp.n168 185
R9502 vgp.n138 vgp.n169 185
R9503 vgp.n140 vgp.n170 185
R9504 vgp.n142 vgp.n171 185
R9505 vgp.n144 vgp.n172 185
R9506 vgp.n146 vgp.n173 185
R9507 vgp.n148 vgp.n174 185
R9508 vgp.n150 vgp.n175 185
R9509 vgp.n152 vgp.n176 185
R9510 vgp.n154 vgp.n177 185
R9511 vgp.n156 vgp.n178 185
R9512 vgp.n158 vgp.n179 9.2683
R9513 vgp.n120 vgp.n122 27.1064
R9514 vgp.n122 vgp.n124 27.1064
R9515 vgp.n124 vgp.n126 27.1064
R9516 vgp.n126 vgp.n128 27.1064
R9517 vgp.n128 vgp.n130 27.1064
R9518 vgp.n130 vgp.n132 27.1064
R9519 vgp.n132 vgp.n134 27.1064
R9520 vgp.n134 vgp.n136 27.1064
R9521 vgp.n136 vgp.n138 27.1064
R9522 vgp.n138 vgp.n140 27.1064
R9523 vgp.n140 vgp.n142 27.1064
R9524 vgp.n142 vgp.n144 27.1064
R9525 vgp.n144 vgp.n146 27.1064
R9526 vgp.n146 vgp.n148 27.1064
R9527 vgp.n148 vgp.n150 27.1064
R9528 vgp.n150 vgp.n152 27.1064
R9529 vgp.n152 vgp.n154 27.1064
R9530 vgp.n154 vgp.n156 27.1064
R9531 vgp.n156 vgp.n158 27.1064
R9532 vgp.n179 vgp.n180 25.7818
R9533 vgp.n160 vgp.n161 256.483
R9534 vgp.n161 vgp.n162 144
R9535 vgp.n162 vgp.n163 144
R9536 vgp.n163 vgp.n164 144
R9537 vgp.n164 vgp.n165 144
R9538 vgp.n165 vgp.n166 144
R9539 vgp.n166 vgp.n167 144
R9540 vgp.n167 vgp.n168 144
R9541 vgp.n168 vgp.n169 144
R9542 vgp.n169 vgp.t4 72.0005
R9543 vgp.n170 vgp.t4 72.0005
R9544 vgp.n170 vgp.n171 144
R9545 vgp.n171 vgp.n172 144
R9546 vgp.n172 vgp.n173 144
R9547 vgp.n173 vgp.n174 144
R9548 vgp.n174 vgp.n175 144
R9549 vgp.n175 vgp.n176 144
R9550 vgp.n176 vgp.n177 144
R9551 vgp.n177 vgp.n178 144
R9552 vgp.n178 vgp.n179 256.483
R9553 vmiler.n29 vmiler.n5 50.6672
R9554 vmiler.n32 vmiler.n31 17.8167
R9555 vmiler.n33 vmiler.n32 15.9293
R9556 vmiler.n24 vmiler.n6 13.1662
R9557 vmiler.n28 vmiler.n6 13.1662
R9558 vmiler.n30 vmiler.n4 13.1662
R9559 vmiler.n26 vmiler.n25 13.1662
R9560 vmiler.n27 vmiler.n26 13.1662
R9561 vmiler.n24 vmiler.n23 9.3308
R9562 vmiler.n25 vmiler.n24 9.3005
R9563 vmiler.n8 vmiler.n6 9.3005
R9564 vmiler.n26 vmiler.n6 9.3005
R9565 vmiler.n28 vmiler.n7 9.3005
R9566 vmiler.n28 vmiler.n27 9.3005
R9567 vmiler.n30 vmiler.n0 9.3005
R9568 vmiler.n31 vmiler.n30 9.3005
R9569 vmiler.n4 vmiler.n1 9.3005
R9570 vmiler.n25 vmiler.t0 7.31479
R9571 vmiler.n30 vmiler.n29 6.94907
R9572 vmiler.n31 vmiler.n5 6.94907
R9573 vmiler.n29 vmiler.n28 6.21764
R9574 vmiler.n27 vmiler.n5 6.21764
R9575 vmiler.n36 vmiler.n35 4.5005
R9576 vmiler.n34 vmiler.n33 4.5005
R9577 vmiler.n23 vmiler.n22 4.5005
R9578 vmiler.n21 vmiler.n20 4.5005
R9579 vmiler.n10 vmiler.n7 4.5005
R9580 vmiler.n15 vmiler.n14 4.5005
R9581 vmiler.n22 vmiler.n9 3.4393
R9582 vmiler.n34 vmiler.n3 3.4393
R9583 vmiler.n17 vmiler.n12 3.4105
R9584 vmiler.n19 vmiler.n18 3.4105
R9585 vmiler.n17 vmiler.n16 3.4105
R9586 vmiler.n13 vmiler.n2 3.4105
R9587 vmiler.n32 vmiler.n4 2.72607
R9588 vmiler.n12 vmiler.n9 1.70842
R9589 vmiler.n11 vmiler.n3 1.70776
R9590 vmiler.n11 vmiler.t1 0.448399
R9591 vmiler.n22 vmiler.n21 0.121712
R9592 vmiler.n35 vmiler.n34 0.121712
R9593 vmiler.n20 vmiler.n7 0.121712
R9594 vmiler.n14 vmiler.n7 0.121712
R9595 vmiler.n23 vmiler.n8 0.106561
R9596 vmiler.n19 vmiler.n10 0.0914091
R9597 vmiler.n15 vmiler.n2 0.0914091
R9598 vmiler.n33 vmiler.n1 0.0914091
R9599 vmiler vmiler.n0 0.0781515
R9600 vmiler.n16 vmiler.n10 0.0611061
R9601 vmiler.n16 vmiler.n15 0.0611061
R9602 vmiler.n18 vmiler.n17 0.0574697
R9603 vmiler.n17 vmiler.n13 0.0574697
R9604 vmiler.n21 vmiler.n19 0.030803
R9605 vmiler.n35 vmiler.n2 0.030803
R9606 vmiler.n36 vmiler.n1 0.030803
R9607 vmiler.n18 vmiler.n9 0.0291946
R9608 vmiler.n13 vmiler.n3 0.0291946
R9609 vmiler vmiler.n36 0.0289091
R9610 vmiler.n20 vmiler.n8 0.0156515
R9611 vmiler.n14 vmiler.n0 0.0156515
R9612 vmiler.n12 vmiler.n11 0.00116197
R9613 a_8092_n1713.n5 a_8092_n1713.n4 50.6672
R9614 a_8092_n1713.n18 a_8092_n1713.n7 50.6672
R9615 a_8092_n1713.n11 a_8092_n1713.n10 17.8167
R9616 a_8092_n1713.n17 a_8092_n1713.n8 17.8167
R9617 a_8092_n1713.n10 a_8092_n1713.n9 15.8839
R9618 a_8092_n1713.n9 a_8092_n1713.n8 15.8839
R9619 a_8092_n1713.n16 a_8092_n1713.n15 13.1662
R9620 a_8092_n1713.n20 a_8092_n1713.n1 13.1662
R9621 a_8092_n1713.n28 a_8092_n1713.n1 13.1662
R9622 a_8092_n1713.n24 a_8092_n1713.n23 13.1662
R9623 a_8092_n1713.n25 a_8092_n1713.n24 13.1662
R9624 a_8092_n1713.n13 a_8092_n1713.n12 13.1662
R9625 a_8092_n1713.n22 a_8092_n1713.n3 13.1662
R9626 a_8092_n1713.n26 a_8092_n1713.n3 13.1662
R9627 a_8092_n1713.n19 a_8092_n1713.n0 13.1662
R9628 a_8092_n1713.n29 a_8092_n1713.n0 13.1662
R9629 a_8092_n1713.n14 a_8092_n1713.n13 9.3005
R9630 a_8092_n1713.n12 a_8092_n1713.n6 9.3005
R9631 a_8092_n1713.n12 a_8092_n1713.n11 9.3005
R9632 a_8092_n1713.n22 a_8092_n1713.n21 9.3005
R9633 a_8092_n1713.n23 a_8092_n1713.n22 9.3005
R9634 a_8092_n1713.n3 a_8092_n1713.n2 9.3005
R9635 a_8092_n1713.n24 a_8092_n1713.n3 9.3005
R9636 a_8092_n1713.n27 a_8092_n1713.n26 9.3005
R9637 a_8092_n1713.n26 a_8092_n1713.n25 9.3005
R9638 a_8092_n1713.n15 a_8092_n1713.n14 9.3005
R9639 a_8092_n1713.n16 a_8092_n1713.n6 9.3005
R9640 a_8092_n1713.n17 a_8092_n1713.n16 9.3005
R9641 a_8092_n1713.n21 a_8092_n1713.n20 9.3005
R9642 a_8092_n1713.n20 a_8092_n1713.n19 9.3005
R9643 a_8092_n1713.n2 a_8092_n1713.n1 9.3005
R9644 a_8092_n1713.n1 a_8092_n1713.n0 9.3005
R9645 a_8092_n1713.n28 a_8092_n1713.n27 9.3005
R9646 a_8092_n1713.n29 a_8092_n1713.n28 9.3005
R9647 a_8092_n1713.n25 a_8092_n1713.t1 7.13193
R9648 a_8092_n1713.t0 a_8092_n1713.n29 7.13193
R9649 a_8092_n1713.n16 a_8092_n1713.n7 6.76621
R9650 a_8092_n1713.n11 a_8092_n1713.n4 6.76621
R9651 a_8092_n1713.n12 a_8092_n1713.n5 6.76621
R9652 a_8092_n1713.n18 a_8092_n1713.n17 6.76621
R9653 a_8092_n1713.n20 a_8092_n1713.n7 6.4005
R9654 a_8092_n1713.n23 a_8092_n1713.n4 6.4005
R9655 a_8092_n1713.n22 a_8092_n1713.n5 6.4005
R9656 a_8092_n1713.n19 a_8092_n1713.n18 6.4005
R9657 a_8092_n1713.n15 a_8092_n1713.n8 2.72607
R9658 a_8092_n1713.n13 a_8092_n1713.n10 2.72607
R9659 a_8092_n1713.n14 a_8092_n1713.n9 0.0282778
R9660 a_8092_n1713.n14 a_8092_n1713.n6 0.0282778
R9661 a_8092_n1713.n21 a_8092_n1713.n6 0.0282778
R9662 a_8092_n1713.n21 a_8092_n1713.n2 0.0282778
R9663 a_8092_n1713.n27 a_8092_n1713.n2 0.0282778
R9664 a_4664_n1459.n13 a_4664_n1459.n12 50.6672
R9665 a_4664_n1459.n22 a_4664_n1459.n6 50.6672
R9666 a_4664_n1459.n16 a_4664_n1459.n15 17.8167
R9667 a_4664_n1459.n21 a_4664_n1459.n7 17.8167
R9668 a_4664_n1459.n17 a_4664_n1459.n7 15.8839
R9669 a_4664_n1459.n17 a_4664_n1459.n16 15.8839
R9670 a_4664_n1459.n28 a_4664_n1459.n1 13.1662
R9671 a_4664_n1459.n24 a_4664_n1459.n1 13.1662
R9672 a_4664_n1459.n20 a_4664_n1459.n19 13.1662
R9673 a_4664_n1459.n10 a_4664_n1459.n9 13.1662
R9674 a_4664_n1459.n11 a_4664_n1459.n10 13.1662
R9675 a_4664_n1459.n3 a_4664_n1459.n2 13.1662
R9676 a_4664_n1459.n4 a_4664_n1459.n3 13.1662
R9677 a_4664_n1459.n14 a_4664_n1459.n8 13.1662
R9678 a_4664_n1459.n29 a_4664_n1459.n0 13.1662
R9679 a_4664_n1459.n23 a_4664_n1459.n0 13.1662
R9680 a_4664_n1459.n27 a_4664_n1459.n2 9.3005
R9681 a_4664_n1459.n9 a_4664_n1459.n2 9.3005
R9682 a_4664_n1459.n26 a_4664_n1459.n3 9.3005
R9683 a_4664_n1459.n10 a_4664_n1459.n3 9.3005
R9684 a_4664_n1459.n25 a_4664_n1459.n4 9.3005
R9685 a_4664_n1459.n11 a_4664_n1459.n4 9.3005
R9686 a_4664_n1459.n14 a_4664_n1459.n5 9.3005
R9687 a_4664_n1459.n15 a_4664_n1459.n14 9.3005
R9688 a_4664_n1459.n18 a_4664_n1459.n8 9.3005
R9689 a_4664_n1459.n28 a_4664_n1459.n27 9.3005
R9690 a_4664_n1459.n29 a_4664_n1459.n28 9.3005
R9691 a_4664_n1459.n26 a_4664_n1459.n1 9.3005
R9692 a_4664_n1459.n1 a_4664_n1459.n0 9.3005
R9693 a_4664_n1459.n25 a_4664_n1459.n24 9.3005
R9694 a_4664_n1459.n24 a_4664_n1459.n23 9.3005
R9695 a_4664_n1459.n20 a_4664_n1459.n5 9.3005
R9696 a_4664_n1459.n21 a_4664_n1459.n20 9.3005
R9697 a_4664_n1459.n19 a_4664_n1459.n18 9.3005
R9698 a_4664_n1459.n9 a_4664_n1459.t1 7.31479
R9699 a_4664_n1459.t0 a_4664_n1459.n29 7.31479
R9700 a_4664_n1459.n20 a_4664_n1459.n6 6.94907
R9701 a_4664_n1459.n15 a_4664_n1459.n12 6.94907
R9702 a_4664_n1459.n14 a_4664_n1459.n13 6.94907
R9703 a_4664_n1459.n22 a_4664_n1459.n21 6.94907
R9704 a_4664_n1459.n24 a_4664_n1459.n6 6.21764
R9705 a_4664_n1459.n12 a_4664_n1459.n11 6.21764
R9706 a_4664_n1459.n13 a_4664_n1459.n4 6.21764
R9707 a_4664_n1459.n23 a_4664_n1459.n22 6.21764
R9708 a_4664_n1459.n16 a_4664_n1459.n8 2.72607
R9709 a_4664_n1459.n19 a_4664_n1459.n7 2.72607
R9710 a_4664_n1459.n27 a_4664_n1459.n26 0.0291624
R9711 a_4664_n1459.n26 a_4664_n1459.n25 0.0291624
R9712 a_4664_n1459.n25 a_4664_n1459.n5 0.0291624
R9713 a_4664_n1459.n18 a_4664_n1459.n5 0.0291624
R9714 a_4664_n1459.n18 a_4664_n1459.n17 0.0291624
R9715 a_8092_n1205.n5 a_8092_n1205.n4 50.6672
R9716 a_8092_n1205.n18 a_8092_n1205.n7 50.6672
R9717 a_8092_n1205.n11 a_8092_n1205.n10 17.8167
R9718 a_8092_n1205.n17 a_8092_n1205.n8 17.8167
R9719 a_8092_n1205.n10 a_8092_n1205.n9 15.8839
R9720 a_8092_n1205.n9 a_8092_n1205.n8 15.8839
R9721 a_8092_n1205.n16 a_8092_n1205.n15 13.1662
R9722 a_8092_n1205.n20 a_8092_n1205.n1 13.1662
R9723 a_8092_n1205.n28 a_8092_n1205.n1 13.1662
R9724 a_8092_n1205.n24 a_8092_n1205.n23 13.1662
R9725 a_8092_n1205.n25 a_8092_n1205.n24 13.1662
R9726 a_8092_n1205.n13 a_8092_n1205.n12 13.1662
R9727 a_8092_n1205.n22 a_8092_n1205.n3 13.1662
R9728 a_8092_n1205.n26 a_8092_n1205.n3 13.1662
R9729 a_8092_n1205.n19 a_8092_n1205.n0 13.1662
R9730 a_8092_n1205.n29 a_8092_n1205.n0 13.1662
R9731 a_8092_n1205.n14 a_8092_n1205.n13 9.3005
R9732 a_8092_n1205.n12 a_8092_n1205.n6 9.3005
R9733 a_8092_n1205.n12 a_8092_n1205.n11 9.3005
R9734 a_8092_n1205.n22 a_8092_n1205.n21 9.3005
R9735 a_8092_n1205.n23 a_8092_n1205.n22 9.3005
R9736 a_8092_n1205.n3 a_8092_n1205.n2 9.3005
R9737 a_8092_n1205.n24 a_8092_n1205.n3 9.3005
R9738 a_8092_n1205.n27 a_8092_n1205.n26 9.3005
R9739 a_8092_n1205.n26 a_8092_n1205.n25 9.3005
R9740 a_8092_n1205.n15 a_8092_n1205.n14 9.3005
R9741 a_8092_n1205.n16 a_8092_n1205.n6 9.3005
R9742 a_8092_n1205.n17 a_8092_n1205.n16 9.3005
R9743 a_8092_n1205.n21 a_8092_n1205.n20 9.3005
R9744 a_8092_n1205.n20 a_8092_n1205.n19 9.3005
R9745 a_8092_n1205.n2 a_8092_n1205.n1 9.3005
R9746 a_8092_n1205.n1 a_8092_n1205.n0 9.3005
R9747 a_8092_n1205.n28 a_8092_n1205.n27 9.3005
R9748 a_8092_n1205.n29 a_8092_n1205.n28 9.3005
R9749 a_8092_n1205.n25 a_8092_n1205.t1 7.13193
R9750 a_8092_n1205.t0 a_8092_n1205.n29 7.13193
R9751 a_8092_n1205.n16 a_8092_n1205.n7 6.76621
R9752 a_8092_n1205.n11 a_8092_n1205.n4 6.76621
R9753 a_8092_n1205.n12 a_8092_n1205.n5 6.76621
R9754 a_8092_n1205.n18 a_8092_n1205.n17 6.76621
R9755 a_8092_n1205.n20 a_8092_n1205.n7 6.4005
R9756 a_8092_n1205.n23 a_8092_n1205.n4 6.4005
R9757 a_8092_n1205.n22 a_8092_n1205.n5 6.4005
R9758 a_8092_n1205.n19 a_8092_n1205.n18 6.4005
R9759 a_8092_n1205.n15 a_8092_n1205.n8 2.72607
R9760 a_8092_n1205.n13 a_8092_n1205.n10 2.72607
R9761 a_8092_n1205.n14 a_8092_n1205.n9 0.0282778
R9762 a_8092_n1205.n14 a_8092_n1205.n6 0.0282778
R9763 a_8092_n1205.n21 a_8092_n1205.n6 0.0282778
R9764 a_8092_n1205.n21 a_8092_n1205.n2 0.0282778
R9765 a_8092_n1205.n27 a_8092_n1205.n2 0.0282778
R9766 a_4664_n951.n13 a_4664_n951.n12 50.6672
R9767 a_4664_n951.n22 a_4664_n951.n6 50.6672
R9768 a_4664_n951.n16 a_4664_n951.n15 17.8167
R9769 a_4664_n951.n21 a_4664_n951.n7 17.8167
R9770 a_4664_n951.n17 a_4664_n951.n7 15.8839
R9771 a_4664_n951.n17 a_4664_n951.n16 15.8839
R9772 a_4664_n951.n28 a_4664_n951.n1 13.1662
R9773 a_4664_n951.n24 a_4664_n951.n1 13.1662
R9774 a_4664_n951.n20 a_4664_n951.n19 13.1662
R9775 a_4664_n951.n10 a_4664_n951.n9 13.1662
R9776 a_4664_n951.n11 a_4664_n951.n10 13.1662
R9777 a_4664_n951.n3 a_4664_n951.n2 13.1662
R9778 a_4664_n951.n4 a_4664_n951.n3 13.1662
R9779 a_4664_n951.n14 a_4664_n951.n8 13.1662
R9780 a_4664_n951.n29 a_4664_n951.n0 13.1662
R9781 a_4664_n951.n23 a_4664_n951.n0 13.1662
R9782 a_4664_n951.n27 a_4664_n951.n2 9.3005
R9783 a_4664_n951.n9 a_4664_n951.n2 9.3005
R9784 a_4664_n951.n26 a_4664_n951.n3 9.3005
R9785 a_4664_n951.n10 a_4664_n951.n3 9.3005
R9786 a_4664_n951.n25 a_4664_n951.n4 9.3005
R9787 a_4664_n951.n11 a_4664_n951.n4 9.3005
R9788 a_4664_n951.n14 a_4664_n951.n5 9.3005
R9789 a_4664_n951.n15 a_4664_n951.n14 9.3005
R9790 a_4664_n951.n18 a_4664_n951.n8 9.3005
R9791 a_4664_n951.n28 a_4664_n951.n27 9.3005
R9792 a_4664_n951.n29 a_4664_n951.n28 9.3005
R9793 a_4664_n951.n26 a_4664_n951.n1 9.3005
R9794 a_4664_n951.n1 a_4664_n951.n0 9.3005
R9795 a_4664_n951.n25 a_4664_n951.n24 9.3005
R9796 a_4664_n951.n24 a_4664_n951.n23 9.3005
R9797 a_4664_n951.n20 a_4664_n951.n5 9.3005
R9798 a_4664_n951.n21 a_4664_n951.n20 9.3005
R9799 a_4664_n951.n19 a_4664_n951.n18 9.3005
R9800 a_4664_n951.n9 a_4664_n951.t1 7.31479
R9801 a_4664_n951.t0 a_4664_n951.n29 7.31479
R9802 a_4664_n951.n20 a_4664_n951.n6 6.94907
R9803 a_4664_n951.n15 a_4664_n951.n12 6.94907
R9804 a_4664_n951.n14 a_4664_n951.n13 6.94907
R9805 a_4664_n951.n22 a_4664_n951.n21 6.94907
R9806 a_4664_n951.n24 a_4664_n951.n6 6.21764
R9807 a_4664_n951.n12 a_4664_n951.n11 6.21764
R9808 a_4664_n951.n13 a_4664_n951.n4 6.21764
R9809 a_4664_n951.n23 a_4664_n951.n22 6.21764
R9810 a_4664_n951.n16 a_4664_n951.n8 2.72607
R9811 a_4664_n951.n19 a_4664_n951.n7 2.72607
R9812 a_4664_n951.n27 a_4664_n951.n26 0.0290714
R9813 a_4664_n951.n26 a_4664_n951.n25 0.0290714
R9814 a_4664_n951.n25 a_4664_n951.n5 0.0290714
R9815 a_4664_n951.n18 a_4664_n951.n5 0.0290714
R9816 a_4664_n951.n18 a_4664_n951.n17 0.0290714
R9817 a_8092_n697.n5 a_8092_n697.n4 50.6672
R9818 a_8092_n697.n18 a_8092_n697.n7 50.6672
R9819 a_8092_n697.n11 a_8092_n697.n10 17.8167
R9820 a_8092_n697.n17 a_8092_n697.n8 17.8167
R9821 a_8092_n697.n10 a_8092_n697.n9 15.8839
R9822 a_8092_n697.n9 a_8092_n697.n8 15.8839
R9823 a_8092_n697.n16 a_8092_n697.n15 13.1662
R9824 a_8092_n697.n20 a_8092_n697.n1 13.1662
R9825 a_8092_n697.n28 a_8092_n697.n1 13.1662
R9826 a_8092_n697.n24 a_8092_n697.n23 13.1662
R9827 a_8092_n697.n25 a_8092_n697.n24 13.1662
R9828 a_8092_n697.n13 a_8092_n697.n12 13.1662
R9829 a_8092_n697.n22 a_8092_n697.n3 13.1662
R9830 a_8092_n697.n26 a_8092_n697.n3 13.1662
R9831 a_8092_n697.n19 a_8092_n697.n0 13.1662
R9832 a_8092_n697.n29 a_8092_n697.n0 13.1662
R9833 a_8092_n697.n14 a_8092_n697.n13 9.3005
R9834 a_8092_n697.n12 a_8092_n697.n6 9.3005
R9835 a_8092_n697.n12 a_8092_n697.n11 9.3005
R9836 a_8092_n697.n22 a_8092_n697.n21 9.3005
R9837 a_8092_n697.n23 a_8092_n697.n22 9.3005
R9838 a_8092_n697.n3 a_8092_n697.n2 9.3005
R9839 a_8092_n697.n24 a_8092_n697.n3 9.3005
R9840 a_8092_n697.n27 a_8092_n697.n26 9.3005
R9841 a_8092_n697.n26 a_8092_n697.n25 9.3005
R9842 a_8092_n697.n15 a_8092_n697.n14 9.3005
R9843 a_8092_n697.n16 a_8092_n697.n6 9.3005
R9844 a_8092_n697.n17 a_8092_n697.n16 9.3005
R9845 a_8092_n697.n21 a_8092_n697.n20 9.3005
R9846 a_8092_n697.n20 a_8092_n697.n19 9.3005
R9847 a_8092_n697.n2 a_8092_n697.n1 9.3005
R9848 a_8092_n697.n1 a_8092_n697.n0 9.3005
R9849 a_8092_n697.n28 a_8092_n697.n27 9.3005
R9850 a_8092_n697.n29 a_8092_n697.n28 9.3005
R9851 a_8092_n697.n25 a_8092_n697.t1 7.13193
R9852 a_8092_n697.t0 a_8092_n697.n29 7.13193
R9853 a_8092_n697.n16 a_8092_n697.n7 6.76621
R9854 a_8092_n697.n11 a_8092_n697.n4 6.76621
R9855 a_8092_n697.n12 a_8092_n697.n5 6.76621
R9856 a_8092_n697.n18 a_8092_n697.n17 6.76621
R9857 a_8092_n697.n20 a_8092_n697.n7 6.4005
R9858 a_8092_n697.n23 a_8092_n697.n4 6.4005
R9859 a_8092_n697.n22 a_8092_n697.n5 6.4005
R9860 a_8092_n697.n19 a_8092_n697.n18 6.4005
R9861 a_8092_n697.n15 a_8092_n697.n8 2.72607
R9862 a_8092_n697.n13 a_8092_n697.n10 2.72607
R9863 a_8092_n697.n14 a_8092_n697.n9 0.0282778
R9864 a_8092_n697.n14 a_8092_n697.n6 0.0282778
R9865 a_8092_n697.n21 a_8092_n697.n6 0.0282778
R9866 a_8092_n697.n21 a_8092_n697.n2 0.0282778
R9867 a_8092_n697.n27 a_8092_n697.n2 0.0282778
R9868 vo1.n412 vo1.n411 285.877
R9869 vo1.n412 vo1.n141 285.877
R9870 vo1.n412 vo1.n140 285.877
R9871 vo1.n412 vo1.n139 285.877
R9872 vo1.n412 vo1.n138 285.877
R9873 vo1.n413 vo1.n412 285.877
R9874 vo1.n412 vo1.n137 285.877
R9875 vo1.n412 vo1.n97 285.877
R9876 vo1.n412 vo1.n96 285.877
R9877 vo1.n445 vo1.n444 285.877
R9878 vo1.n445 vo1.n15 285.877
R9879 vo1.n445 vo1.n14 285.877
R9880 vo1.n445 vo1.n13 285.877
R9881 vo1.n445 vo1.n12 285.877
R9882 vo1.n445 vo1.n11 285.877
R9883 vo1.n445 vo1.n10 285.877
R9884 vo1.n446 vo1.n445 285.877
R9885 vo1.n445 vo1.n9 285.877
R9886 vo1.n391 vo1.n390 152
R9887 vo1.n371 vo1.n370 152
R9888 vo1.n351 vo1.n350 152
R9889 vo1.n330 vo1.n329 152
R9890 vo1.n309 vo1.n308 152
R9891 vo1.n288 vo1.n287 152
R9892 vo1.n268 vo1.n267 152
R9893 vo1.n248 vo1.n247 152
R9894 vo1.n391 vo1.n169 109.918
R9895 vo1.n392 vo1.n391 109.918
R9896 vo1.n371 vo1.n178 109.918
R9897 vo1.n372 vo1.n371 109.918
R9898 vo1.n351 vo1.n187 109.918
R9899 vo1.n352 vo1.n351 109.918
R9900 vo1.n330 vo1.n195 109.918
R9901 vo1.n331 vo1.n330 109.918
R9902 vo1.n309 vo1.n203 109.918
R9903 vo1.n310 vo1.n309 109.918
R9904 vo1.n288 vo1.n211 109.918
R9905 vo1.n289 vo1.n288 109.918
R9906 vo1.n268 vo1.n220 109.918
R9907 vo1.n269 vo1.n268 109.918
R9908 vo1.n248 vo1.n229 109.918
R9909 vo1.n249 vo1.n248 109.918
R9910 vo1.n110 vo1.n108 86.1871
R9911 vo1.n111 vo1.n110 86.1871
R9912 vo1.n452 vo1.n451 86.1871
R9913 vo1.n453 vo1.n452 86.1871
R9914 vo1.n62 vo1.n61 50.6672
R9915 vo1.n406 vo1.n142 27.1064
R9916 vo1.n403 vo1.n402 27.1064
R9917 vo1.n161 vo1.n160 27.1064
R9918 vo1.n157 vo1.n156 27.1064
R9919 vo1.n414 vo1.n94 27.1064
R9920 vo1.n136 vo1.n95 27.1064
R9921 vo1.n129 vo1.n98 27.1064
R9922 vo1.n126 vo1.n125 27.1064
R9923 vo1.n117 vo1.n116 27.1064
R9924 vo1.n390 vo1.n170 27.1064
R9925 vo1.n390 vo1.n168 27.1064
R9926 vo1.n370 vo1.n179 27.1064
R9927 vo1.n370 vo1.n177 27.1064
R9928 vo1.n350 vo1.n188 27.1064
R9929 vo1.n350 vo1.n186 27.1064
R9930 vo1.n329 vo1.n196 27.1064
R9931 vo1.n329 vo1.n194 27.1064
R9932 vo1.n308 vo1.n204 27.1064
R9933 vo1.n308 vo1.n202 27.1064
R9934 vo1.n287 vo1.n212 27.1064
R9935 vo1.n287 vo1.n210 27.1064
R9936 vo1.n267 vo1.n221 27.1064
R9937 vo1.n267 vo1.n219 27.1064
R9938 vo1.n247 vo1.n230 27.1064
R9939 vo1.n247 vo1.n228 27.1064
R9940 vo1.n443 vo1.n17 27.1064
R9941 vo1.n436 vo1.n16 27.1064
R9942 vo1.n433 vo1.n432 27.1064
R9943 vo1.n425 vo1.n424 27.1064
R9944 vo1.n53 vo1.n52 27.1064
R9945 vo1.n49 vo1.n48 27.1064
R9946 vo1.n41 vo1.n40 27.1064
R9947 vo1.n37 vo1.n8 27.1064
R9948 vo1.n4 vo1.n3 27.1064
R9949 vo1.n378 vo1.n169 23.0638
R9950 vo1.n393 vo1.n392 23.0638
R9951 vo1.n358 vo1.n178 23.0638
R9952 vo1.n373 vo1.n372 23.0638
R9953 vo1.n337 vo1.n187 23.0638
R9954 vo1.n353 vo1.n352 23.0638
R9955 vo1.n316 vo1.n195 23.0638
R9956 vo1.n332 vo1.n331 23.0638
R9957 vo1.n295 vo1.n203 23.0638
R9958 vo1.n311 vo1.n310 23.0638
R9959 vo1.n275 vo1.n211 23.0638
R9960 vo1.n290 vo1.n289 23.0638
R9961 vo1.n255 vo1.n220 23.0638
R9962 vo1.n270 vo1.n269 23.0638
R9963 vo1.n234 vo1.n229 23.0638
R9964 vo1.n250 vo1.n249 23.0638
R9965 vo1.n411 vo1.n410 22.6179
R9966 vo1.n21 vo1.n9 22.6179
R9967 vo1.n105 vo1.n96 22.5549
R9968 vo1.n447 vo1.n446 22.5549
R9969 vo1.n114 vo1.n111 21.9523
R9970 vo1.n119 vo1.n108 21.9523
R9971 vo1.n454 vo1.n453 21.9523
R9972 vo1.n451 vo1.n450 21.9523
R9973 vo1.n110 vo1.t7 20.0005
R9974 vo1.n110 vo1.t5 20.0005
R9975 vo1.n452 vo1.t4 20.0005
R9976 vo1.n452 vo1.t8 20.0005
R9977 vo1.n87 vo1.n86 17.8167
R9978 vo1.n88 vo1.n87 15.9293
R9979 vo1.n411 vo1.n142 13.2471
R9980 vo1.n403 vo1.n141 13.2471
R9981 vo1.n160 vo1.n140 13.2471
R9982 vo1.n157 vo1.n139 13.2471
R9983 vo1.n138 vo1.n94 13.2471
R9984 vo1.n413 vo1.n95 13.2471
R9985 vo1.n137 vo1.n98 13.2471
R9986 vo1.n126 vo1.n97 13.2471
R9987 vo1.n406 vo1.n141 13.2471
R9988 vo1.n402 vo1.n140 13.2471
R9989 vo1.n161 vo1.n139 13.2471
R9990 vo1.n156 vo1.n138 13.2471
R9991 vo1.n414 vo1.n413 13.2471
R9992 vo1.n137 vo1.n136 13.2471
R9993 vo1.n129 vo1.n97 13.2471
R9994 vo1.n125 vo1.n96 13.2471
R9995 vo1.n444 vo1.n16 13.2471
R9996 vo1.n433 vo1.n15 13.2471
R9997 vo1.n424 vo1.n14 13.2471
R9998 vo1.n52 vo1.n13 13.2471
R9999 vo1.n49 vo1.n12 13.2471
R10000 vo1.n40 vo1.n11 13.2471
R10001 vo1.n37 vo1.n10 13.2471
R10002 vo1.n17 vo1.n9 13.2471
R10003 vo1.n444 vo1.n443 13.2471
R10004 vo1.n436 vo1.n15 13.2471
R10005 vo1.n432 vo1.n14 13.2471
R10006 vo1.n425 vo1.n13 13.2471
R10007 vo1.n53 vo1.n12 13.2471
R10008 vo1.n48 vo1.n11 13.2471
R10009 vo1.n41 vo1.n10 13.2471
R10010 vo1.n446 vo1.n8 13.2471
R10011 vo1.n72 vo1.n67 13.1662
R10012 vo1.n72 vo1.n68 13.1662
R10013 vo1.n85 vo1.n60 13.1662
R10014 vo1.n71 vo1.n69 13.1662
R10015 vo1.n71 vo1.n70 13.1662
R10016 vo1.n117 vo1.n108 12.6288
R10017 vo1.n116 vo1.n111 12.6288
R10018 vo1.n451 vo1.n4 12.6288
R10019 vo1.n453 vo1.n3 12.6288
R10020 vo1.n391 vo1.t16 12.0505
R10021 vo1.n371 vo1.t15 12.0505
R10022 vo1.n351 vo1.t14 12.0505
R10023 vo1.n330 vo1.t13 12.0505
R10024 vo1.n309 vo1.t12 12.0505
R10025 vo1.n288 vo1.t11 12.0505
R10026 vo1.n268 vo1.t10 12.0505
R10027 vo1.n248 vo1.t9 12.0505
R10028 vo1.n392 vo1.n168 11.3247
R10029 vo1.n170 vo1.n169 11.3247
R10030 vo1.n372 vo1.n177 11.3247
R10031 vo1.n179 vo1.n178 11.3247
R10032 vo1.n352 vo1.n186 11.3247
R10033 vo1.n188 vo1.n187 11.3247
R10034 vo1.n331 vo1.n194 11.3247
R10035 vo1.n196 vo1.n195 11.3247
R10036 vo1.n310 vo1.n202 11.3247
R10037 vo1.n204 vo1.n203 11.3247
R10038 vo1.n289 vo1.n210 11.3247
R10039 vo1.n212 vo1.n211 11.3247
R10040 vo1.n269 vo1.n219 11.3247
R10041 vo1.n221 vo1.n220 11.3247
R10042 vo1.n249 vo1.n228 11.3247
R10043 vo1.n230 vo1.n229 11.3247
R10044 vo1.n67 vo1.n66 9.3308
R10045 vo1.n143 vo1.n142 9.3005
R10046 vo1.n407 vo1.n406 9.3005
R10047 vo1.n404 vo1.n403 9.3005
R10048 vo1.n402 vo1.n401 9.3005
R10049 vo1.n160 vo1.n146 9.3005
R10050 vo1.n162 vo1.n161 9.3005
R10051 vo1.n158 vo1.n157 9.3005
R10052 vo1.n156 vo1.n155 9.3005
R10053 vo1.n150 vo1.n94 9.3005
R10054 vo1.n415 vo1.n414 9.3005
R10055 vo1.n99 vo1.n95 9.3005
R10056 vo1.n136 vo1.n135 9.3005
R10057 vo1.n101 vo1.n98 9.3005
R10058 vo1.n130 vo1.n129 9.3005
R10059 vo1.n127 vo1.n126 9.3005
R10060 vo1.n125 vo1.n124 9.3005
R10061 vo1.n118 vo1.n117 9.3005
R10062 vo1.n116 vo1.n115 9.3005
R10063 vo1.n172 vo1.n168 9.3005
R10064 vo1.n390 vo1.n389 9.3005
R10065 vo1.n379 vo1.n170 9.3005
R10066 vo1.n181 vo1.n177 9.3005
R10067 vo1.n370 vo1.n369 9.3005
R10068 vo1.n359 vo1.n179 9.3005
R10069 vo1.n189 vo1.n186 9.3005
R10070 vo1.n350 vo1.n349 9.3005
R10071 vo1.n339 vo1.n188 9.3005
R10072 vo1.n197 vo1.n194 9.3005
R10073 vo1.n329 vo1.n328 9.3005
R10074 vo1.n318 vo1.n196 9.3005
R10075 vo1.n205 vo1.n202 9.3005
R10076 vo1.n308 vo1.n307 9.3005
R10077 vo1.n297 vo1.n204 9.3005
R10078 vo1.n214 vo1.n210 9.3005
R10079 vo1.n287 vo1.n286 9.3005
R10080 vo1.n276 vo1.n212 9.3005
R10081 vo1.n223 vo1.n219 9.3005
R10082 vo1.n267 vo1.n266 9.3005
R10083 vo1.n256 vo1.n221 9.3005
R10084 vo1.n231 vo1.n228 9.3005
R10085 vo1.n247 vo1.n246 9.3005
R10086 vo1.n236 vo1.n230 9.3005
R10087 vo1.n34 vo1.n8 9.3005
R10088 vo1.n38 vo1.n37 9.3005
R10089 vo1.n42 vo1.n41 9.3005
R10090 vo1.n40 vo1.n31 9.3005
R10091 vo1.n48 vo1.n47 9.3005
R10092 vo1.n50 vo1.n49 9.3005
R10093 vo1.n54 vo1.n53 9.3005
R10094 vo1.n52 vo1.n28 9.3005
R10095 vo1.n426 vo1.n425 9.3005
R10096 vo1.n424 vo1.n25 9.3005
R10097 vo1.n432 vo1.n431 9.3005
R10098 vo1.n434 vo1.n433 9.3005
R10099 vo1.n437 vo1.n436 9.3005
R10100 vo1.n19 vo1.n16 9.3005
R10101 vo1.n443 vo1.n442 9.3005
R10102 vo1.n20 vo1.n17 9.3005
R10103 vo1.n5 vo1.n4 9.3005
R10104 vo1.n3 vo1.n1 9.3005
R10105 vo1.n69 vo1.n67 9.3005
R10106 vo1.n73 vo1.n72 9.3005
R10107 vo1.n72 vo1.n71 9.3005
R10108 vo1.n68 vo1.n63 9.3005
R10109 vo1.n70 vo1.n68 9.3005
R10110 vo1.n85 vo1.n84 9.3005
R10111 vo1.n86 vo1.n85 9.3005
R10112 vo1.n60 vo1.n59 9.3005
R10113 vo1.n412 vo1.t0 7.57742
R10114 vo1.n412 vo1.t2 7.57742
R10115 vo1.n445 vo1.t1 7.57742
R10116 vo1.n445 vo1.t3 7.57742
R10117 vo1.n69 vo1.t6 7.31479
R10118 vo1.n85 vo1.n62 6.94907
R10119 vo1.n86 vo1.n61 6.94907
R10120 vo1.n68 vo1.n62 6.21764
R10121 vo1.n70 vo1.n61 6.21764
R10122 vo1.n114 vo1.n113 4.6255
R10123 vo1.n455 vo1.n454 4.6255
R10124 vo1.n394 vo1.n393 4.53459
R10125 vo1.n374 vo1.n373 4.53459
R10126 vo1.n255 vo1.n254 4.53459
R10127 vo1.n337 vo1.n336 4.5308
R10128 vo1.n354 vo1.n353 4.5308
R10129 vo1.n316 vo1.n315 4.5308
R10130 vo1.n333 vo1.n332 4.5308
R10131 vo1.n295 vo1.n294 4.5308
R10132 vo1.n312 vo1.n311 4.5308
R10133 vo1.n275 vo1.n274 4.5308
R10134 vo1.n291 vo1.n290 4.5308
R10135 vo1.n234 vo1.n233 4.5308
R10136 vo1.n251 vo1.n250 4.5308
R10137 vo1.n378 vo1.n377 4.52702
R10138 vo1.n358 vo1.n357 4.52702
R10139 vo1.n271 vo1.n270 4.52702
R10140 vo1.n147 vo1.n145 4.5005
R10141 vo1.n405 vo1.n144 4.5005
R10142 vo1.n409 vo1.n408 4.5005
R10143 vo1.n109 vo1.n107 4.5005
R10144 vo1.n120 vo1.n119 4.5005
R10145 vo1.n113 vo1.n112 4.5005
R10146 vo1.n123 vo1.n122 4.5005
R10147 vo1.n106 vo1.n104 4.5005
R10148 vo1.n128 vo1.n103 4.5005
R10149 vo1.n132 vo1.n131 4.5005
R10150 vo1.n134 vo1.n133 4.5005
R10151 vo1.n102 vo1.n100 4.5005
R10152 vo1.n93 vo1.n92 4.5005
R10153 vo1.n121 vo1.n105 4.5005
R10154 vo1.n417 vo1.n416 4.5005
R10155 vo1.n151 vo1.n91 4.5005
R10156 vo1.n154 vo1.n153 4.5005
R10157 vo1.n152 vo1.n149 4.5005
R10158 vo1.n159 vo1.n148 4.5005
R10159 vo1.n164 vo1.n163 4.5005
R10160 vo1.n400 vo1.n399 4.5005
R10161 vo1.n388 vo1.n387 4.5005
R10162 vo1.n167 vo1.n166 4.5005
R10163 vo1.n381 vo1.n380 4.5005
R10164 vo1.n173 vo1.n171 4.5005
R10165 vo1.n368 vo1.n367 4.5005
R10166 vo1.n176 vo1.n175 4.5005
R10167 vo1.n361 vo1.n360 4.5005
R10168 vo1.n182 vo1.n180 4.5005
R10169 vo1.n348 vo1.n347 4.5005
R10170 vo1.n185 vo1.n184 4.5005
R10171 vo1.n341 vo1.n340 4.5005
R10172 vo1.n338 vo1.n190 4.5005
R10173 vo1.n327 vo1.n326 4.5005
R10174 vo1.n193 vo1.n192 4.5005
R10175 vo1.n320 vo1.n319 4.5005
R10176 vo1.n317 vo1.n198 4.5005
R10177 vo1.n306 vo1.n305 4.5005
R10178 vo1.n201 vo1.n200 4.5005
R10179 vo1.n299 vo1.n298 4.5005
R10180 vo1.n296 vo1.n206 4.5005
R10181 vo1.n285 vo1.n284 4.5005
R10182 vo1.n209 vo1.n208 4.5005
R10183 vo1.n278 vo1.n277 4.5005
R10184 vo1.n215 vo1.n213 4.5005
R10185 vo1.n265 vo1.n264 4.5005
R10186 vo1.n218 vo1.n217 4.5005
R10187 vo1.n258 vo1.n257 4.5005
R10188 vo1.n224 vo1.n222 4.5005
R10189 vo1.n245 vo1.n244 4.5005
R10190 vo1.n227 vo1.n226 4.5005
R10191 vo1.n238 vo1.n237 4.5005
R10192 vo1.n235 vo1.n232 4.5005
R10193 vo1.n22 vo1.n18 4.5005
R10194 vo1.n441 vo1.n440 4.5005
R10195 vo1.n439 vo1.n438 4.5005
R10196 vo1.n435 vo1.n23 4.5005
R10197 vo1.n26 vo1.n24 4.5005
R10198 vo1.n430 vo1.n429 4.5005
R10199 vo1.n428 vo1.n427 4.5005
R10200 vo1.n423 vo1.n27 4.5005
R10201 vo1.n422 vo1.n421 4.5005
R10202 vo1.n2 vo1.n0 4.5005
R10203 vo1.n450 vo1.n449 4.5005
R10204 vo1.n456 vo1.n455 4.5005
R10205 vo1.n51 vo1.n29 4.5005
R10206 vo1.n32 vo1.n30 4.5005
R10207 vo1.n46 vo1.n45 4.5005
R10208 vo1.n44 vo1.n43 4.5005
R10209 vo1.n39 vo1.n33 4.5005
R10210 vo1.n36 vo1.n35 4.5005
R10211 vo1.n7 vo1.n6 4.5005
R10212 vo1.n448 vo1.n447 4.5005
R10213 vo1.n56 vo1.n55 4.5005
R10214 vo1.n83 vo1.n58 4.5005
R10215 vo1.n89 vo1.n88 4.5005
R10216 vo1.n66 vo1.n65 4.5005
R10217 vo1.n75 vo1.n74 4.5005
R10218 vo1.n64 vo1.n63 4.5005
R10219 vo1.n82 vo1.n81 4.5005
R10220 vo1.n397 vo1.n396 4.34366
R10221 vo1.n420 vo1.n419 4.34366
R10222 vo1.n240 vo1.n233 3.46747
R10223 vo1.n77 vo1.n65 3.46747
R10224 vo1.n243 vo1.n225 3.4105
R10225 vo1.n252 vo1.n251 3.4105
R10226 vo1.n240 vo1.n239 3.4105
R10227 vo1.n242 vo1.n241 3.4105
R10228 vo1.n263 vo1.n216 3.4105
R10229 vo1.n272 vo1.n271 3.4105
R10230 vo1.n254 vo1.n253 3.4105
R10231 vo1.n260 vo1.n259 3.4105
R10232 vo1.n262 vo1.n261 3.4105
R10233 vo1.n283 vo1.n207 3.4105
R10234 vo1.n292 vo1.n291 3.4105
R10235 vo1.n274 vo1.n273 3.4105
R10236 vo1.n280 vo1.n279 3.4105
R10237 vo1.n282 vo1.n281 3.4105
R10238 vo1.n304 vo1.n199 3.4105
R10239 vo1.n313 vo1.n312 3.4105
R10240 vo1.n294 vo1.n293 3.4105
R10241 vo1.n301 vo1.n300 3.4105
R10242 vo1.n303 vo1.n302 3.4105
R10243 vo1.n325 vo1.n191 3.4105
R10244 vo1.n334 vo1.n333 3.4105
R10245 vo1.n315 vo1.n314 3.4105
R10246 vo1.n322 vo1.n321 3.4105
R10247 vo1.n324 vo1.n323 3.4105
R10248 vo1.n346 vo1.n183 3.4105
R10249 vo1.n355 vo1.n354 3.4105
R10250 vo1.n336 vo1.n335 3.4105
R10251 vo1.n343 vo1.n342 3.4105
R10252 vo1.n345 vo1.n344 3.4105
R10253 vo1.n366 vo1.n174 3.4105
R10254 vo1.n375 vo1.n374 3.4105
R10255 vo1.n357 vo1.n356 3.4105
R10256 vo1.n363 vo1.n362 3.4105
R10257 vo1.n365 vo1.n364 3.4105
R10258 vo1.n386 vo1.n165 3.4105
R10259 vo1.n395 vo1.n394 3.4105
R10260 vo1.n377 vo1.n376 3.4105
R10261 vo1.n383 vo1.n382 3.4105
R10262 vo1.n385 vo1.n384 3.4105
R10263 vo1.n398 vo1.n397 3.4105
R10264 vo1.n419 vo1.n418 3.4105
R10265 vo1.n90 vo1.n89 3.4105
R10266 vo1.n77 vo1.n76 3.4105
R10267 vo1.n79 vo1.n78 3.4105
R10268 vo1.n80 vo1.n57 3.4105
R10269 vo1.n87 vo1.n60 2.72607
R10270 vo1.n410 vo1.n409 2.376
R10271 vo1.n22 vo1.n21 2.376
R10272 vo1.n121 vo1.n120 1.44217
R10273 vo1.n449 vo1.n448 1.44217
R10274 vo1.n419 vo1.n90 0.943572
R10275 vo1.n397 vo1.n395 0.938933
R10276 vo1.n273 vo1.n272 0.13737
R10277 vo1.n356 vo1.n355 0.13737
R10278 vo1.n293 vo1.n292 0.135803
R10279 vo1.n314 vo1.n313 0.135803
R10280 vo1.n335 vo1.n334 0.135803
R10281 vo1.n376 vo1.n375 0.135803
R10282 vo1.n253 vo1.n252 0.134236
R10283 vo1.n409 vo1.n144 0.1255
R10284 vo1.n147 vo1.n144 0.1255
R10285 vo1.n154 vo1.n151 0.1255
R10286 vo1.n123 vo1.n105 0.1255
R10287 vo1.n120 vo1.n107 0.1255
R10288 vo1.n113 vo1.n107 0.1255
R10289 vo1.n102 vo1.n92 0.1255
R10290 vo1.n133 vo1.n102 0.1255
R10291 vo1.n133 vo1.n132 0.1255
R10292 vo1.n132 vo1.n103 0.1255
R10293 vo1.n106 vo1.n103 0.1255
R10294 vo1.n122 vo1.n106 0.1255
R10295 vo1.n122 vo1.n121 0.1255
R10296 vo1.n164 vo1.n148 0.1255
R10297 vo1.n152 vo1.n148 0.1255
R10298 vo1.n153 vo1.n152 0.1255
R10299 vo1.n153 vo1.n91 0.1255
R10300 vo1.n429 vo1.n26 0.1255
R10301 vo1.n429 vo1.n428 0.1255
R10302 vo1.n428 vo1.n27 0.1255
R10303 vo1.n421 vo1.n27 0.1255
R10304 vo1.n440 vo1.n22 0.1255
R10305 vo1.n440 vo1.n439 0.1255
R10306 vo1.n447 vo1.n7 0.1255
R10307 vo1.n449 vo1.n2 0.1255
R10308 vo1.n455 vo1.n2 0.1255
R10309 vo1.n32 vo1.n29 0.1255
R10310 vo1.n45 vo1.n32 0.1255
R10311 vo1.n45 vo1.n44 0.1255
R10312 vo1.n44 vo1.n33 0.1255
R10313 vo1.n35 vo1.n33 0.1255
R10314 vo1.n35 vo1.n6 0.1255
R10315 vo1.n448 vo1.n6 0.1255
R10316 vo1.n399 vo1.n147 0.123389
R10317 vo1.n439 vo1.n23 0.123389
R10318 vo1.n381 vo1.n377 0.121712
R10319 vo1.n394 vo1.n166 0.121712
R10320 vo1.n361 vo1.n357 0.121712
R10321 vo1.n374 vo1.n175 0.121712
R10322 vo1.n341 vo1.n336 0.121712
R10323 vo1.n354 vo1.n184 0.121712
R10324 vo1.n320 vo1.n315 0.121712
R10325 vo1.n333 vo1.n192 0.121712
R10326 vo1.n299 vo1.n294 0.121712
R10327 vo1.n312 vo1.n200 0.121712
R10328 vo1.n278 vo1.n274 0.121712
R10329 vo1.n291 vo1.n208 0.121712
R10330 vo1.n258 vo1.n254 0.121712
R10331 vo1.n271 vo1.n217 0.121712
R10332 vo1.n238 vo1.n233 0.121712
R10333 vo1.n251 vo1.n226 0.121712
R10334 vo1.n75 vo1.n65 0.121712
R10335 vo1.n89 vo1.n58 0.121712
R10336 vo1.n74 vo1.n63 0.121712
R10337 vo1.n82 vo1.n63 0.121712
R10338 vo1.n417 vo1.n92 0.119166
R10339 vo1.n56 vo1.n29 0.119166
R10340 vo1.n408 vo1.n143 0.117688
R10341 vo1.n155 vo1.n149 0.117688
R10342 vo1.n124 vo1.n104 0.117688
R10343 vo1.n119 vo1.n118 0.117688
R10344 vo1.n115 vo1.n114 0.117688
R10345 vo1.n20 vo1.n18 0.117688
R10346 vo1.n427 vo1.n426 0.117688
R10347 vo1.n55 vo1.n28 0.117688
R10348 vo1.n36 vo1.n34 0.117688
R10349 vo1.n450 vo1.n5 0.117688
R10350 vo1.n454 vo1.n1 0.117688
R10351 vo1.n73 vo1.n66 0.106561
R10352 vo1.n84 vo1.n83 0.106561
R10353 vo1.n407 vo1.n405 0.102062
R10354 vo1.n159 vo1.n158 0.102062
R10355 vo1.n415 vo1.n93 0.102062
R10356 vo1.n128 vo1.n127 0.102062
R10357 vo1 vo1.n109 0.102062
R10358 vo1.n442 vo1.n441 0.102062
R10359 vo1.n430 vo1.n25 0.102062
R10360 vo1.n54 vo1.n51 0.102062
R10361 vo1.n39 vo1.n38 0.102062
R10362 vo1 vo1.n0 0.102062
R10363 vo1.n418 vo1.n91 0.099212
R10364 vo1.n421 vo1.n420 0.099212
R10365 vo1.n380 vo1.n378 0.095197
R10366 vo1.n360 vo1.n358 0.095197
R10367 vo1.n270 vo1.n218 0.095197
R10368 vo1.n423 vo1 0.09425
R10369 vo1.n382 vo1.n173 0.0914091
R10370 vo1.n387 vo1.n386 0.0914091
R10371 vo1.n362 vo1.n182 0.0914091
R10372 vo1.n367 vo1.n366 0.0914091
R10373 vo1.n340 vo1.n337 0.0914091
R10374 vo1.n353 vo1.n185 0.0914091
R10375 vo1.n342 vo1.n190 0.0914091
R10376 vo1.n347 vo1.n346 0.0914091
R10377 vo1.n319 vo1.n316 0.0914091
R10378 vo1.n332 vo1.n193 0.0914091
R10379 vo1.n321 vo1.n198 0.0914091
R10380 vo1.n326 vo1.n325 0.0914091
R10381 vo1.n298 vo1.n295 0.0914091
R10382 vo1.n311 vo1.n201 0.0914091
R10383 vo1.n300 vo1.n206 0.0914091
R10384 vo1.n305 vo1.n304 0.0914091
R10385 vo1.n277 vo1.n275 0.0914091
R10386 vo1.n290 vo1.n209 0.0914091
R10387 vo1.n279 vo1.n215 0.0914091
R10388 vo1.n284 vo1.n283 0.0914091
R10389 vo1.n259 vo1.n224 0.0914091
R10390 vo1.n264 vo1.n263 0.0914091
R10391 vo1.n237 vo1.n234 0.0914091
R10392 vo1.n250 vo1.n227 0.0914091
R10393 vo1.n239 vo1.n232 0.0914091
R10394 vo1.n244 vo1.n243 0.0914091
R10395 vo1.n76 vo1.n64 0.0914091
R10396 vo1.n81 vo1.n80 0.0914091
R10397 vo1.n88 vo1.n59 0.0914091
R10398 vo1.n393 vo1.n167 0.0876212
R10399 vo1.n373 vo1.n176 0.0876212
R10400 vo1.n257 vo1.n255 0.0876212
R10401 vo1.n404 vo1.n145 0.0864375
R10402 vo1.n163 vo1.n162 0.0864375
R10403 vo1.n100 vo1.n99 0.0864375
R10404 vo1.n131 vo1.n130 0.0864375
R10405 vo1.n438 vo1.n19 0.0864375
R10406 vo1.n431 vo1.n24 0.0864375
R10407 vo1.n50 vo1.n30 0.0864375
R10408 vo1.n43 vo1.n42 0.0864375
R10409 vo1.n416 vo1 0.0844844
R10410 vo1.n379 vo1.n171 0.0800455
R10411 vo1.n359 vo1.n180 0.0800455
R10412 vo1.n265 vo1.n223 0.0800455
R10413 vo1.n339 vo1.n338 0.0762576
R10414 vo1.n348 vo1.n189 0.0762576
R10415 vo1.n318 vo1.n317 0.0762576
R10416 vo1.n327 vo1.n197 0.0762576
R10417 vo1.n297 vo1.n296 0.0762576
R10418 vo1.n306 vo1.n205 0.0762576
R10419 vo1.n276 vo1.n213 0.0762576
R10420 vo1.n285 vo1.n214 0.0762576
R10421 vo1.n236 vo1.n235 0.0762576
R10422 vo1.n245 vo1.n231 0.0762576
R10423 vo1.n368 vo1.n181 0.0724697
R10424 vo1.n256 vo1.n222 0.0724697
R10425 vo1.n401 vo1.n400 0.0708125
R10426 vo1.n400 vo1.n146 0.0708125
R10427 vo1.n135 vo1.n134 0.0708125
R10428 vo1.n134 vo1.n101 0.0708125
R10429 vo1.n437 vo1.n435 0.0708125
R10430 vo1.n435 vo1.n434 0.0708125
R10431 vo1.n47 vo1.n46 0.0708125
R10432 vo1.n46 vo1.n31 0.0708125
R10433 vo1.n410 vo1.n143 0.0696233
R10434 vo1.n21 vo1.n20 0.0696233
R10435 vo1.n398 vo1.n164 0.067962
R10436 vo1.n396 vo1.n26 0.067962
R10437 vo1.n389 vo1.n388 0.0648939
R10438 vo1.n266 vo1.n222 0.0648939
R10439 vo1.n385 vo1.n173 0.0611061
R10440 vo1.n387 vo1.n385 0.0611061
R10441 vo1.n365 vo1.n182 0.0611061
R10442 vo1.n367 vo1.n365 0.0611061
R10443 vo1.n349 vo1.n348 0.0611061
R10444 vo1.n345 vo1.n190 0.0611061
R10445 vo1.n347 vo1.n345 0.0611061
R10446 vo1.n328 vo1.n327 0.0611061
R10447 vo1.n324 vo1.n198 0.0611061
R10448 vo1.n326 vo1.n324 0.0611061
R10449 vo1.n307 vo1.n306 0.0611061
R10450 vo1.n303 vo1.n206 0.0611061
R10451 vo1.n305 vo1.n303 0.0611061
R10452 vo1.n286 vo1.n213 0.0611061
R10453 vo1.n282 vo1.n215 0.0611061
R10454 vo1.n284 vo1.n282 0.0611061
R10455 vo1.n262 vo1.n224 0.0611061
R10456 vo1.n264 vo1.n262 0.0611061
R10457 vo1.n246 vo1.n245 0.0611061
R10458 vo1.n242 vo1.n232 0.0611061
R10459 vo1.n244 vo1.n242 0.0611061
R10460 vo1.n79 vo1.n64 0.0611061
R10461 vo1.n81 vo1.n79 0.0611061
R10462 vo1.n241 vo1.n240 0.0574697
R10463 vo1.n241 vo1.n225 0.0574697
R10464 vo1.n252 vo1.n225 0.0574697
R10465 vo1.n260 vo1.n253 0.0574697
R10466 vo1.n261 vo1.n260 0.0574697
R10467 vo1.n261 vo1.n216 0.0574697
R10468 vo1.n272 vo1.n216 0.0574697
R10469 vo1.n280 vo1.n273 0.0574697
R10470 vo1.n281 vo1.n280 0.0574697
R10471 vo1.n281 vo1.n207 0.0574697
R10472 vo1.n292 vo1.n207 0.0574697
R10473 vo1.n301 vo1.n293 0.0574697
R10474 vo1.n302 vo1.n301 0.0574697
R10475 vo1.n302 vo1.n199 0.0574697
R10476 vo1.n313 vo1.n199 0.0574697
R10477 vo1.n322 vo1.n314 0.0574697
R10478 vo1.n323 vo1.n322 0.0574697
R10479 vo1.n323 vo1.n191 0.0574697
R10480 vo1.n334 vo1.n191 0.0574697
R10481 vo1.n343 vo1.n335 0.0574697
R10482 vo1.n344 vo1.n343 0.0574697
R10483 vo1.n344 vo1.n183 0.0574697
R10484 vo1.n355 vo1.n183 0.0574697
R10485 vo1.n363 vo1.n356 0.0574697
R10486 vo1.n364 vo1.n363 0.0574697
R10487 vo1.n364 vo1.n174 0.0574697
R10488 vo1.n375 vo1.n174 0.0574697
R10489 vo1.n383 vo1.n376 0.0574697
R10490 vo1.n384 vo1.n383 0.0574697
R10491 vo1.n384 vo1.n165 0.0574697
R10492 vo1.n395 vo1.n165 0.0574697
R10493 vo1.n389 vo1.n171 0.0573182
R10494 vo1.n369 vo1.n180 0.0573182
R10495 vo1.n296 vo1 0.0573182
R10496 vo1.n78 vo1.n77 0.0556792
R10497 vo1.n401 vo1.n145 0.0551875
R10498 vo1.n163 vo1.n146 0.0551875
R10499 vo1.n135 vo1.n100 0.0551875
R10500 vo1.n131 vo1.n101 0.0551875
R10501 vo1.n438 vo1.n437 0.0551875
R10502 vo1.n434 vo1.n24 0.0551875
R10503 vo1.n47 vo1.n30 0.0551875
R10504 vo1.n43 vo1.n31 0.0551875
R10505 vo1.n78 vo1.n57 0.0542143
R10506 vo1.n90 vo1.n57 0.0542143
R10507 vo1.n172 vo1.n167 0.0497424
R10508 vo1.n181 vo1.n176 0.0497424
R10509 vo1.n257 vo1.n256 0.0497424
R10510 vo1.n340 vo1.n339 0.0459545
R10511 vo1.n189 vo1.n185 0.0459545
R10512 vo1.n319 vo1.n318 0.0459545
R10513 vo1.n197 vo1.n193 0.0459545
R10514 vo1.n298 vo1.n297 0.0459545
R10515 vo1.n205 vo1.n201 0.0459545
R10516 vo1.n277 vo1.n276 0.0459545
R10517 vo1.n214 vo1.n209 0.0459545
R10518 vo1.n237 vo1.n236 0.0459545
R10519 vo1.n231 vo1.n227 0.0459545
R10520 vo1.n399 vo1.n398 0.0427297
R10521 vo1.n396 vo1.n23 0.0427297
R10522 vo1.n380 vo1.n379 0.0421667
R10523 vo1.n360 vo1.n359 0.0421667
R10524 vo1.n223 vo1.n218 0.0421667
R10525 vo1.n388 vo1 0.0402727
R10526 vo1.n405 vo1.n404 0.0395625
R10527 vo1.n162 vo1.n159 0.0395625
R10528 vo1.n99 vo1.n93 0.0395625
R10529 vo1.n130 vo1.n128 0.0395625
R10530 vo1.n441 vo1.n19 0.0395625
R10531 vo1.n431 vo1.n430 0.0395625
R10532 vo1.n51 vo1.n50 0.0395625
R10533 vo1.n42 vo1.n39 0.0395625
R10534 vo1.n150 vo1 0.0337031
R10535 vo1 vo1.n172 0.032697
R10536 vo1.n369 vo1 0.032697
R10537 vo1 vo1.n368 0.032697
R10538 vo1.n349 vo1 0.032697
R10539 vo1.n328 vo1 0.032697
R10540 vo1.n286 vo1 0.032697
R10541 vo1.n266 vo1 0.032697
R10542 vo1.n246 vo1 0.032697
R10543 vo1 vo1.n422 0.03175
R10544 vo1.n382 vo1.n381 0.030803
R10545 vo1.n386 vo1.n166 0.030803
R10546 vo1.n362 vo1.n361 0.030803
R10547 vo1.n366 vo1.n175 0.030803
R10548 vo1.n342 vo1.n341 0.030803
R10549 vo1.n346 vo1.n184 0.030803
R10550 vo1.n321 vo1.n320 0.030803
R10551 vo1.n325 vo1.n192 0.030803
R10552 vo1.n300 vo1.n299 0.030803
R10553 vo1.n304 vo1.n200 0.030803
R10554 vo1.n279 vo1.n278 0.030803
R10555 vo1.n283 vo1.n208 0.030803
R10556 vo1.n259 vo1.n258 0.030803
R10557 vo1.n263 vo1.n217 0.030803
R10558 vo1.n239 vo1.n238 0.030803
R10559 vo1.n243 vo1.n226 0.030803
R10560 vo1.n76 vo1.n75 0.030803
R10561 vo1.n80 vo1.n58 0.030803
R10562 vo1.n83 vo1.n59 0.030803
R10563 vo1.n338 vo1 0.0289091
R10564 vo1.n317 vo1 0.0289091
R10565 vo1 vo1.n285 0.0289091
R10566 vo1.n235 vo1 0.0289091
R10567 vo1 vo1.n265 0.0251212
R10568 vo1.n408 vo1.n407 0.0239375
R10569 vo1.n158 vo1.n149 0.0239375
R10570 vo1.n416 vo1.n415 0.0239375
R10571 vo1.n127 vo1.n104 0.0239375
R10572 vo1.n112 vo1 0.0239375
R10573 vo1.n442 vo1.n18 0.0239375
R10574 vo1.n427 vo1.n25 0.0239375
R10575 vo1.n55 vo1.n54 0.0239375
R10576 vo1.n38 vo1.n36 0.0239375
R10577 vo1 vo1.n456 0.0239375
R10578 vo1.n418 vo1.n417 0.0157027
R10579 vo1.n420 vo1.n56 0.0157027
R10580 vo1.n74 vo1.n73 0.0156515
R10581 vo1.n84 vo1.n82 0.0156515
R10582 vo1.n155 vo1.n154 0.0083125
R10583 vo1.n151 vo1.n150 0.0083125
R10584 vo1.n124 vo1.n123 0.0083125
R10585 vo1.n118 vo1.n109 0.0083125
R10586 vo1.n115 vo1.n112 0.0083125
R10587 vo1.n426 vo1.n423 0.0083125
R10588 vo1.n422 vo1.n28 0.0083125
R10589 vo1.n34 vo1.n7 0.0083125
R10590 vo1.n5 vo1.n0 0.0083125
R10591 vo1.n456 vo1.n1 0.0083125
R10592 vo1.n307 vo1 0.00428788
R10593 vd.n1 vd.n0 9.2683
R10594 vd.n0 vd.t11 184.483
R10595 vd.t11 vd.n2 184.483
R10596 vd.n4 vd.n1 9.3005
R10597 vd.n5 vd.n3 9.3005
R10598 vd.n8 vd.n0 25.8052
R10599 vd.n1 vd.n3 27.1064
R10600 vd.n3 vd.n2 9.2683
R10601 vd.n6 vd.n7 4.5005
R10602 vd.n8 vd.n9 4.5005
R10603 vd.n10 vd.n11 4.5005
R10604 vd.n12 vd.n377 4.5005
R10605 vd.n4 vd.n8 0.117688
R10606 vd.n6 vd.n4 0.0083125
R10607 vd vd.n6 0.0239375
R10608 vd vd.n12 0.102062
R10609 vd.n12 vd.n5 0.0083125
R10610 vd.n5 vd.n10 0.117688
R10611 vd.n10 vd.n2 25.8052
R10612 vd.n9 vd.n7 0.1255
R10613 vd.n7 vd.n377 0.1255
R10614 vd.n377 vd.n11 0.1255
R10615 vd.n14 vd.n13 4.5005
R10616 vd.n16 vd.n15 4.5005
R10617 vd.n22 vd.n17 4.5005
R10618 vd.n24 vd.n23 4.5005
R10619 vd.n26 vd.n25 4.5005
R10620 vd vd.n32 4.5005
R10621 vd.n34 vd.n33 4.5005
R10622 vd.n36 vd.n35 4.5005
R10623 vd.n42 vd.n37 4.5005
R10624 vd.n44 vd.n43 4.5005
R10625 vd.n46 vd.n45 4.5005
R10626 vd.n52 vd.n47 4.5005
R10627 vd.n54 vd.n53 4.5005
R10628 vd.n56 vd.n55 4.5005
R10629 vd.n62 vd.n57 4.5005
R10630 vd.n64 vd.n63 4.5005
R10631 vd.n66 vd.n65 4.5005
R10632 vd.n72 vd.n67 4.5005
R10633 vd.n74 vd.n73 4.5005
R10634 vd.n76 vd.n75 4.5005
R10635 vd.n83 vd.n82 4.5005
R10636 vd.n85 vd.n84 4.5005
R10637 vd.n87 vd.n86 4.5005
R10638 vd.n93 vd.n88 4.5005
R10639 vd.n22 vd.n16 0.118147
R10640 vd.n14 vd.n22 0.118147
R10641 vd.n26 vd.n14 0.320353
R10642 vd.n32 vd.n26 0.118147
R10643 vd.n24 vd.n32 0.118147
R10644 vd.n36 vd.n24 0.313
R10645 vd.n42 vd.n36 0.118147
R10646 vd.n34 vd.n42 0.118147
R10647 vd.n46 vd.n34 0.316676
R10648 vd.n52 vd.n46 0.118147
R10649 vd.n44 vd.n52 0.118147
R10650 vd.n94 vd.n44 0.158588
R10651 vd.n56 vd.n94 0.158588
R10652 vd.n62 vd.n56 0.118147
R10653 vd.n54 vd.n62 0.118147
R10654 vd.n66 vd.n54 0.316676
R10655 vd.n72 vd.n66 0.118147
R10656 vd.n64 vd.n72 0.118147
R10657 vd.n76 vd.n64 0.320353
R10658 vd.n83 vd.n76 0.118147
R10659 vd.n74 vd.n83 0.118147
R10660 vd.n87 vd.n74 0.313
R10661 vd.n93 vd.n87 0.118147
R10662 vd.n85 vd.n93 0.118147
R10663 vd.n9 vd.n85 0.322145
R10664 vd.n96 vd.n95 4.5005
R10665 vd.n98 vd.n97 4.5005
R10666 vd.n100 vd.n99 4.5005
R10667 vd.n108 vd.n107 4.5005
R10668 vd.n16 vd.n98 0.294618
R10669 vd.n98 vd.n96 0.118147
R10670 vd.n96 vd.n108 0.118147
R10671 vd.n108 vd.n100 0.118147
R10672 vd.n110 vd.n109 4.5005
R10673 vd.n111 vd.n112 4.5005
R10674 vd.n113 vd.n114 4.5005
R10675 vd.n100 vd.n110 1.43711
R10676 vd.n110 vd.n112 0.1255
R10677 vd.n112 vd.n114 0.1255
R10678 vd.n116 vd.n115 4.5005
R10679 vd.n114 vd.n116 0.11811
R10680 vd.n116 vd.n117 0.00894595
R10681 vd.n302 vd.n301 4.5005
R10682 vd.n303 vd.n304 4.5005
R10683 vd.n305 vd.n306 4.5005
R10684 vd.n307 vd.n308 4.5005
R10685 vd.n309 vd.n310 4.5005
R10686 vd.n312 vd.n311 4.5005
R10687 vd.n313 vd.n314 4.5005
R10688 vd.n315 vd.n316 4.5005
R10689 vd.n317 vd.n318 4.5005
R10690 vd.n319 vd.n320 4.5005
R10691 vd.n321 vd.n322 4.5005
R10692 vd.n323 vd.n324 4.5005
R10693 vd.n325 vd.n326 4.5005
R10694 vd.n327 vd.n328 4.5005
R10695 vd.n117 vd.n302 0.107024
R10696 vd.n302 vd.n304 0.1255
R10697 vd.n304 vd.n306 0.1255
R10698 vd.n306 vd.n308 0.1255
R10699 vd.n308 vd.n310 0.1255
R10700 vd.n310 vd.n312 0.1255
R10701 vd.n312 vd.n314 0.1255
R10702 vd.n314 vd.n316 0.1255
R10703 vd.n316 vd.n318 0.1255
R10704 vd.n318 vd.n320 0.1255
R10705 vd.n320 vd.n322 0.1255
R10706 vd.n322 vd.n324 0.1255
R10707 vd.n324 vd.n326 0.1255
R10708 vd.n326 vd.n328 0.1255
R10709 vd.n328 vd.n300 2.376
R10710 vd.n330 vd.n329 9.3005
R10711 vd.n332 vd.n331 9.3005
R10712 vd.n334 vd.n333 9.3005
R10713 vd.n336 vd.n335 9.3005
R10714 vd.n338 vd.n337 9.3005
R10715 vd.n340 vd.n339 9.3005
R10716 vd.n342 vd.n341 9.3005
R10717 vd.n344 vd.n343 9.3005
R10718 vd.n346 vd.n345 9.3005
R10719 vd.n348 vd.n347 9.3005
R10720 vd.n350 vd.n349 9.3005
R10721 vd.n352 vd.n351 9.3005
R10722 vd.n354 vd.n353 9.3005
R10723 vd.n356 vd.n355 9.3005
R10724 vd.n358 vd.n357 9.3005
R10725 vd.n360 vd.n359 9.3005
R10726 vd.n109 vd.n111 0.1255
R10727 vd.n111 vd.n360 0.0083125
R10728 vd.n360 vd.n113 0.117688
R10729 vd.n113 vd.n358 0.0239375
R10730 vd.n358 vd.n115 0.102062
R10731 vd.n115 vd.n356 0.0395625
R10732 vd.n356 vd.n301 0.0864375
R10733 vd.n301 vd.n354 0.0551875
R10734 vd.n354 vd.n303 0.0708125
R10735 vd.n303 vd.n352 0.0708125
R10736 vd.n352 vd.n305 0.0551875
R10737 vd.n305 vd.n350 0.0864375
R10738 vd.n350 vd.n307 0.0395625
R10739 vd.n307 vd.n348 0.102062
R10740 vd.n348 vd.n309 0.0239375
R10741 vd.n309 vd 0.0102656
R10742 vd vd.n346 0.107922
R10743 vd.n311 vd.n346 0.0083125
R10744 vd.n311 vd.n313 0.1255
R10745 vd.n344 vd.n313 0.0083125
R10746 vd.n315 vd.n344 0.117688
R10747 vd.n342 vd.n315 0.0239375
R10748 vd.n317 vd.n342 0.102062
R10749 vd.n340 vd.n317 0.0395625
R10750 vd.n319 vd.n340 0.0864375
R10751 vd.n338 vd.n319 0.0551875
R10752 vd.n321 vd.n338 0.0708125
R10753 vd.n336 vd.n321 0.0708125
R10754 vd.n323 vd.n336 0.0551875
R10755 vd.n334 vd.n323 0.0864375
R10756 vd.n325 vd.n334 0.0395625
R10757 vd.n332 vd.n325 0.102062
R10758 vd.n327 vd.n332 0.0239375
R10759 vd.n330 vd.n327 0.117688
R10760 vd.n300 vd.n330 0.0696233
R10761 vd.n359 vd.n362 11.0627
R10762 vd.n363 vd.n357 585
R10763 vd.n355 vd.n364 585
R10764 vd.n353 vd.n365 585
R10765 vd.n351 vd.n366 585
R10766 vd.n349 vd.n367 585
R10767 vd.n347 vd.n368 585
R10768 vd.n345 vd.n369 585
R10769 vd.n343 vd.n370 585
R10770 vd.n341 vd.n371 585
R10771 vd.n339 vd.n372 585
R10772 vd.n337 vd.n373 585
R10773 vd.n335 vd.n374 585
R10774 vd.n333 vd.n375 585
R10775 vd.n376 vd.n331 585
R10776 vd.n329 vd.n361 11.0627
R10777 vd.n109 vd.n362 24.8405
R10778 vd.n359 vd.n357 27.1064
R10779 vd.n357 vd.n355 27.1064
R10780 vd.n355 vd.n353 27.1064
R10781 vd.n353 vd.n351 27.1064
R10782 vd.n351 vd.n349 27.1064
R10783 vd.n349 vd.n347 27.1064
R10784 vd.n347 vd.n345 27.1064
R10785 vd.n345 vd.n343 27.1064
R10786 vd.n343 vd.n341 27.1064
R10787 vd.n341 vd.n339 27.1064
R10788 vd.n339 vd.n337 27.1064
R10789 vd.n337 vd.n335 27.1064
R10790 vd.n335 vd.n333 27.1064
R10791 vd.n333 vd.n331 27.1064
R10792 vd.n331 vd.n329 27.1064
R10793 vd.n361 vd.n300 24.9035
R10794 vd.n362 vd.n363 571.606
R10795 vd.n363 vd.n364 236.4
R10796 vd.n364 vd.n365 236.4
R10797 vd.n365 vd.n366 236.4
R10798 vd.n366 vd.n367 236.4
R10799 vd.n367 vd.n368 236.4
R10800 vd.n368 vd.n369 236.4
R10801 vd.n369 vd.t0 118.201
R10802 vd.n370 vd.t0 118.201
R10803 vd.n370 vd.n371 236.4
R10804 vd.n371 vd.n372 236.4
R10805 vd.n372 vd.n373 236.4
R10806 vd.n373 vd.n374 236.4
R10807 vd.n374 vd.n375 236.4
R10808 vd.n375 vd.n376 236.4
R10809 vd.n361 vd.n376 571.606
R10810 vd.n212 vd.n213 3.4105
R10811 vd.n117 vd.n213 4.33113
R10812 vd.n299 vd.n213 4.33113
R10813 vd.n215 vd.n214 4.5005
R10814 vd.n215 vd.n299 0.00556757
R10815 vd.n217 vd.n216 4.5005
R10816 vd.n218 vd.n219 4.5005
R10817 vd.n297 vd.n298 4.5005
R10818 vd.n217 vd.n298 0.1255
R10819 vd.n298 vd.n219 0.1255
R10820 vd.n219 vd.n215 0.117582
R10821 vd.n11 vd.n217 1.44217
R10822 vd.n221 vd.n222 4.5005
R10823 vd.n223 vd.n224 4.5005
R10824 vd.n225 vd.n226 4.5005
R10825 vd.n227 vd.n228 4.5005
R10826 vd.n229 vd.n230 4.5005
R10827 vd.n231 vd.n232 4.5005
R10828 vd.n233 vd.n234 4.5005
R10829 vd.n235 vd.n236 4.5005
R10830 vd.n238 vd.n237 4.5005
R10831 vd.n239 vd.n240 4.5005
R10832 vd.n241 vd.n242 4.5005
R10833 vd.n243 vd.n244 4.5005
R10834 vd.n245 vd.n246 4.5005
R10835 vd.n248 vd.n247 4.5005
R10836 vd.n250 vd.n249 9.3005
R10837 vd.n252 vd.n251 9.3005
R10838 vd.n254 vd.n253 9.3005
R10839 vd.n256 vd.n255 9.3005
R10840 vd.n258 vd.n257 9.3005
R10841 vd.n260 vd.n259 9.3005
R10842 vd.n262 vd.n261 9.3005
R10843 vd.n264 vd.n263 9.3005
R10844 vd.n266 vd.n265 9.3005
R10845 vd.n268 vd.n267 9.3005
R10846 vd.n270 vd.n269 9.3005
R10847 vd.n272 vd.n271 9.3005
R10848 vd.n274 vd.n273 9.3005
R10849 vd.n276 vd.n275 9.3005
R10850 vd.n278 vd.n277 9.3005
R10851 vd.n280 vd.n279 9.3005
R10852 vd.n216 vd.n297 0.1255
R10853 vd.n297 vd.n250 0.0083125
R10854 vd.n250 vd.n218 0.117688
R10855 vd.n218 vd.n252 0.0239375
R10856 vd.n252 vd.n214 0.102062
R10857 vd.n214 vd.n254 0.0395625
R10858 vd.n254 vd.n247 0.0864375
R10859 vd.n247 vd.n256 0.0551875
R10860 vd.n256 vd.n245 0.0708125
R10861 vd.n245 vd.n258 0.0708125
R10862 vd.n258 vd.n243 0.0551875
R10863 vd.n243 vd.n260 0.0864375
R10864 vd.n260 vd.n241 0.0395625
R10865 vd.n241 vd.n262 0.102062
R10866 vd.n262 vd.n239 0.0239375
R10867 vd.n239 vd 0.0102656
R10868 vd vd.n264 0.107922
R10869 vd.n237 vd.n264 0.0083125
R10870 vd.n237 vd.n235 0.1255
R10871 vd.n266 vd.n235 0.0083125
R10872 vd.n233 vd.n266 0.117688
R10873 vd.n268 vd.n233 0.0239375
R10874 vd.n231 vd.n268 0.102062
R10875 vd.n270 vd.n231 0.0395625
R10876 vd.n229 vd.n270 0.0864375
R10877 vd.n272 vd.n229 0.0551875
R10878 vd.n227 vd.n272 0.0708125
R10879 vd.n274 vd.n227 0.0708125
R10880 vd.n225 vd.n274 0.0551875
R10881 vd.n276 vd.n225 0.0864375
R10882 vd.n223 vd.n276 0.0395625
R10883 vd.n278 vd.n223 0.102062
R10884 vd.n221 vd.n278 0.0239375
R10885 vd.n280 vd.n221 0.117688
R10886 vd.n220 vd.n280 0.0696233
R10887 vd.n249 vd.n281 11.0627
R10888 vd.n282 vd.n251 585
R10889 vd.n253 vd.n283 585
R10890 vd.n255 vd.n284 585
R10891 vd.n257 vd.n285 585
R10892 vd.n259 vd.n286 585
R10893 vd.n261 vd.n287 585
R10894 vd.n263 vd.n288 585
R10895 vd.n265 vd.n289 585
R10896 vd.n267 vd.n290 585
R10897 vd.n269 vd.n291 585
R10898 vd.n271 vd.n292 585
R10899 vd.n273 vd.n293 585
R10900 vd.n275 vd.n294 585
R10901 vd.n295 vd.n277 585
R10902 vd.n279 vd.n296 11.0627
R10903 vd.n216 vd.n281 24.8405
R10904 vd.n249 vd.n251 27.1064
R10905 vd.n251 vd.n253 27.1064
R10906 vd.n253 vd.n255 27.1064
R10907 vd.n255 vd.n257 27.1064
R10908 vd.n257 vd.n259 27.1064
R10909 vd.n259 vd.n261 27.1064
R10910 vd.n261 vd.n263 27.1064
R10911 vd.n263 vd.n265 27.1064
R10912 vd.n265 vd.n267 27.1064
R10913 vd.n267 vd.n269 27.1064
R10914 vd.n269 vd.n271 27.1064
R10915 vd.n271 vd.n273 27.1064
R10916 vd.n273 vd.n275 27.1064
R10917 vd.n275 vd.n277 27.1064
R10918 vd.n277 vd.n279 27.1064
R10919 vd.n296 vd.n220 24.9035
R10920 vd.n281 vd.n282 571.606
R10921 vd.n282 vd.n283 236.4
R10922 vd.n283 vd.n284 236.4
R10923 vd.n284 vd.n285 236.4
R10924 vd.n285 vd.n286 236.4
R10925 vd.n286 vd.n287 236.4
R10926 vd.n287 vd.n288 236.4
R10927 vd.n288 vd.t2 118.201
R10928 vd.n289 vd.t2 118.201
R10929 vd.n289 vd.n290 236.4
R10930 vd.n290 vd.n291 236.4
R10931 vd.n291 vd.n292 236.4
R10932 vd.n292 vd.n293 236.4
R10933 vd.n293 vd.n294 236.4
R10934 vd.n294 vd.n295 236.4
R10935 vd.n296 vd.n295 571.606
R10936 vd.n299 vd.n248 0.110931
R10937 vd.n248 vd.n246 0.1255
R10938 vd.n246 vd.n244 0.1255
R10939 vd.n244 vd.n242 0.1255
R10940 vd.n242 vd.n240 0.1255
R10941 vd.n240 vd.n238 0.1255
R10942 vd.n238 vd.n236 0.1255
R10943 vd.n236 vd.n234 0.1255
R10944 vd.n234 vd.n232 0.1255
R10945 vd.n232 vd.n230 0.1255
R10946 vd.n230 vd.n228 0.1255
R10947 vd.n228 vd.n226 0.1255
R10948 vd.n226 vd.n224 0.1255
R10949 vd.n224 vd.n222 0.1255
R10950 vd.n222 vd.n220 2.376
R10951 vd.n119 vd.n118 4.5005
R10952 vd.n119 vd.n212 0.00894595
R10953 vd.n121 vd.n120 4.5005
R10954 vd.n122 vd.n123 4.5005
R10955 vd.n195 vd.n196 4.5005
R10956 vd.n121 vd.n196 0.1255
R10957 vd.n196 vd.n123 0.1255
R10958 vd.n123 vd.n119 0.11811
R10959 vd.n197 vd.n198 4.5005
R10960 vd.n200 vd.n199 4.5005
R10961 vd.n201 vd.n202 4.5005
R10962 vd.n211 vd.n210 4.5005
R10963 vd.n200 vd.n198 0.1255
R10964 vd.n198 vd.n211 0.1255
R10965 vd.n211 vd.n202 0.1255
R10966 vd.n202 vd.n121 1.44217
R10967 vd.n94 vd.n200 0.189302
R10968 vd.n204 vd.n203 9.3005
R10969 vd.n206 vd.n205 9.3005
R10970 vd.n199 vd.n204 0.117688
R10971 vd.n204 vd.n197 0.0083125
R10972 vd.n197 vd 0.0571406
R10973 vd vd.n210 0.0688594
R10974 vd.n210 vd.n206 0.0083125
R10975 vd.n206 vd.n201 0.117688
R10976 vd.n208 vd.n209 86.1871
R10977 vd.n208 vd.n203 12.6288
R10978 vd.n209 vd.n207 86.1871
R10979 vd.n207 vd.n201 21.9523
R10980 vd.n199 vd.n208 21.9523
R10981 vd.n203 vd.n205 27.1064
R10982 vd.n205 vd.n207 12.6288
R10983 vd.n209 vd.t7 20.0005
R10984 vd.n209 vd.t9 20.0005
R10985 vd.n125 vd.n126 4.5005
R10986 vd.n127 vd.n128 4.5005
R10987 vd.n129 vd.n130 4.5005
R10988 vd.n131 vd.n132 4.5005
R10989 vd.n133 vd.n134 4.5005
R10990 vd.n135 vd.n136 4.5005
R10991 vd.n137 vd.n138 4.5005
R10992 vd.n139 vd.n140 4.5005
R10993 vd.n141 vd.n142 4.5005
R10994 vd.n143 vd.n144 4.5005
R10995 vd.n145 vd.n146 4.5005
R10996 vd.n147 vd.n148 4.5005
R10997 vd.n149 vd.n150 4.5005
R10998 vd.n152 vd.n151 4.5005
R10999 vd.n154 vd.n153 9.3005
R11000 vd.n156 vd.n155 9.3005
R11001 vd.n158 vd.n157 9.3005
R11002 vd.n160 vd.n159 9.3005
R11003 vd.n162 vd.n161 9.3005
R11004 vd.n164 vd.n163 9.3005
R11005 vd.n166 vd.n165 9.3005
R11006 vd.n168 vd.n167 9.3005
R11007 vd.n170 vd.n169 9.3005
R11008 vd.n172 vd.n171 9.3005
R11009 vd.n174 vd.n173 9.3005
R11010 vd.n176 vd.n175 9.3005
R11011 vd.n178 vd.n177 9.3005
R11012 vd.n180 vd.n179 9.3005
R11013 vd.n182 vd.n181 9.3005
R11014 vd.n184 vd.n183 9.3005
R11015 vd.n120 vd.n195 0.1255
R11016 vd.n195 vd.n154 0.0083125
R11017 vd.n154 vd.n122 0.117688
R11018 vd.n122 vd.n156 0.0239375
R11019 vd.n156 vd.n118 0.102062
R11020 vd.n118 vd.n158 0.0395625
R11021 vd.n158 vd.n151 0.0864375
R11022 vd.n151 vd.n160 0.0551875
R11023 vd.n160 vd.n149 0.0708125
R11024 vd.n149 vd.n162 0.0708125
R11025 vd.n162 vd.n147 0.0551875
R11026 vd.n147 vd.n164 0.0864375
R11027 vd.n164 vd.n145 0.0395625
R11028 vd.n145 vd.n166 0.102062
R11029 vd.n166 vd.n143 0.0239375
R11030 vd.n143 vd.n168 0.117688
R11031 vd.n168 vd.n141 0.0083125
R11032 vd.n141 vd 0.0258906
R11033 vd vd.n139 0.100109
R11034 vd.n170 vd.n139 0.0083125
R11035 vd.n137 vd.n170 0.117688
R11036 vd.n172 vd.n137 0.0239375
R11037 vd.n135 vd.n172 0.102062
R11038 vd.n174 vd.n135 0.0395625
R11039 vd.n133 vd.n174 0.0864375
R11040 vd.n176 vd.n133 0.0551875
R11041 vd.n131 vd.n176 0.0708125
R11042 vd.n178 vd.n131 0.0708125
R11043 vd.n129 vd.n178 0.0551875
R11044 vd.n180 vd.n129 0.0864375
R11045 vd.n127 vd.n180 0.0395625
R11046 vd.n182 vd.n127 0.102062
R11047 vd.n125 vd.n182 0.0239375
R11048 vd.n184 vd.n125 0.117688
R11049 vd.n124 vd.n184 0.0696233
R11050 vd.n193 vd.n194 285.877
R11051 vd.n193 vd.n153 13.2471
R11052 vd.n194 vd.n192 285.877
R11053 vd.n192 vd.n157 13.2471
R11054 vd.n194 vd.n191 285.877
R11055 vd.n191 vd.n161 13.2471
R11056 vd.n194 vd.n190 285.877
R11057 vd.n190 vd.n165 13.2471
R11058 vd.n194 vd.n189 285.877
R11059 vd.n169 vd.n189 13.2471
R11060 vd.n194 vd.n188 285.877
R11061 vd.n173 vd.n188 13.2471
R11062 vd.n194 vd.n187 285.877
R11063 vd.n177 vd.n187 13.2471
R11064 vd.n194 vd.n186 285.877
R11065 vd.n181 vd.n186 13.2471
R11066 vd.n194 vd.n185 285.877
R11067 vd.n185 vd.n124 22.6179
R11068 vd.n120 vd.n193 22.5549
R11069 vd.n153 vd.n155 27.1064
R11070 vd.n155 vd.n192 13.2471
R11071 vd.n157 vd.n159 27.1064
R11072 vd.n159 vd.n191 13.2471
R11073 vd.n161 vd.n163 27.1064
R11074 vd.n163 vd.n190 13.2471
R11075 vd.n165 vd.n167 27.1064
R11076 vd.n167 vd.n189 13.2471
R11077 vd.n169 vd.n171 27.1064
R11078 vd.n171 vd.n188 13.2471
R11079 vd.n173 vd.n175 27.1064
R11080 vd.n175 vd.n187 13.2471
R11081 vd.n177 vd.n179 27.1064
R11082 vd.n179 vd.n186 13.2471
R11083 vd.n181 vd.n183 27.1064
R11084 vd.n183 vd.n185 13.2471
R11085 vd.n194 vd.t1 7.57742
R11086 vd.n194 vd.t3 7.57742
R11087 vd.n212 vd.n152 0.107024
R11088 vd.n152 vd.n150 0.1255
R11089 vd.n150 vd.n148 0.1255
R11090 vd.n148 vd.n146 0.1255
R11091 vd.n146 vd.n144 0.1255
R11092 vd.n144 vd.n142 0.1255
R11093 vd.n142 vd.n140 0.1255
R11094 vd.n140 vd.n138 0.1255
R11095 vd.n138 vd.n136 0.1255
R11096 vd.n136 vd.n134 0.1255
R11097 vd.n134 vd.n132 0.1255
R11098 vd.n132 vd.n130 0.1255
R11099 vd.n130 vd.n128 0.1255
R11100 vd.n128 vd.n126 0.1255
R11101 vd.n126 vd.n124 2.376
R11102 vd.n102 vd.n101 9.3005
R11103 vd.n104 vd.n103 9.3005
R11104 vd.n97 vd.n102 0.117688
R11105 vd.n102 vd.n95 0.0083125
R11106 vd.n95 vd 0.0239375
R11107 vd vd.n107 0.102062
R11108 vd.n107 vd.n104 0.0083125
R11109 vd.n104 vd.n99 0.117688
R11110 vd.n101 vd.n105 9.2683
R11111 vd.n103 vd.n106 9.2683
R11112 vd.n97 vd.n105 25.8052
R11113 vd.n101 vd.n103 27.1064
R11114 vd.n106 vd.n99 25.8052
R11115 vd.n105 vd.t5 184.483
R11116 vd.t5 vd.n106 184.483
R11117 vd.n88 vd.n90 9.3005
R11118 vd.n86 vd 0.117924
R11119 vd vd.n88 0.00428788
R11120 vd.n88 vd.n84 0.121712
R11121 vd.n84 vd.n89 9.31565
R11122 vd.n90 vd.n91 11.3247
R11123 vd.n86 vd.n91 23.0789
R11124 vd.n90 vd.n89 27.1064
R11125 vd.n91 vd.n92 77.1778
R11126 vd.n92 vd.n89 184.74
R11127 vd.n92 vd.t10 36.1505
R11128 vd.n79 vd.n78 9.3005
R11129 vd.n75 vd.n79 0.117924
R11130 vd.n82 vd.n79 0.00428788
R11131 vd.n82 vd 0.0289091
R11132 vd vd.n73 0.093303
R11133 vd.n73 vd.n77 9.31186
R11134 vd.n78 vd.n80 11.3247
R11135 vd.n75 vd.n80 23.0827
R11136 vd.n78 vd.n77 27.1064
R11137 vd.n80 vd.n81 77.1778
R11138 vd.n81 vd.n77 184.74
R11139 vd.n81 vd.t12 36.1505
R11140 vd.n67 vd.n69 9.3005
R11141 vd.n65 vd.n67 0.121712
R11142 vd.n67 vd 0.00807576
R11143 vd vd.n63 0.114136
R11144 vd.n63 vd.n68 9.31565
R11145 vd.n69 vd.n70 11.3247
R11146 vd.n65 vd.n70 23.0789
R11147 vd.n69 vd.n68 27.1064
R11148 vd.n70 vd.n71 77.1778
R11149 vd.n71 vd.n68 184.74
R11150 vd.n71 vd.t13 36.1505
R11151 vd.n57 vd.n59 9.3005
R11152 vd.n55 vd 0.0895151
R11153 vd vd.n57 0.0156515
R11154 vd.n57 vd.n53 0.121712
R11155 vd.n53 vd.n58 9.31565
R11156 vd.n59 vd.n60 11.3247
R11157 vd.n55 vd.n60 23.0789
R11158 vd.n59 vd.n58 27.1064
R11159 vd.n60 vd.n61 77.1778
R11160 vd.n61 vd.n58 184.74
R11161 vd.n61 vd.t8 36.1505
R11162 vd.n47 vd.n49 9.3005
R11163 vd.n45 vd 0.0895151
R11164 vd vd.n47 0.032697
R11165 vd.n47 vd.n43 0.121712
R11166 vd.n43 vd.n48 9.31565
R11167 vd.n49 vd.n50 11.3247
R11168 vd.n45 vd.n50 23.0789
R11169 vd.n49 vd.n48 27.1064
R11170 vd.n50 vd.n51 77.1778
R11171 vd.n51 vd.n48 184.74
R11172 vd.n51 vd.t6 36.1505
R11173 vd.n37 vd.n39 9.3005
R11174 vd.n35 vd.n37 0.121712
R11175 vd.n37 vd 0.032697
R11176 vd vd.n33 0.0895151
R11177 vd.n33 vd.n38 9.31565
R11178 vd.n39 vd.n40 11.3247
R11179 vd.n35 vd.n40 23.0789
R11180 vd.n39 vd.n38 27.1064
R11181 vd.n40 vd.n41 77.1778
R11182 vd.n41 vd.n38 184.74
R11183 vd.n41 vd.t14 36.1505
R11184 vd.n29 vd.n28 9.3005
R11185 vd.n25 vd.n29 0.117924
R11186 vd.n29 vd 0.00428788
R11187 vd vd.n23 0.121712
R11188 vd.n23 vd.n27 9.31186
R11189 vd.n28 vd.n30 11.3247
R11190 vd.n25 vd.n30 23.0827
R11191 vd.n28 vd.n27 27.1064
R11192 vd.n30 vd.n31 77.1778
R11193 vd.n31 vd.n27 184.74
R11194 vd.n31 vd.t15 36.1505
R11195 vd.n17 vd.n19 9.3005
R11196 vd.n15 vd 0.106561
R11197 vd vd.n17 0.0156515
R11198 vd.n17 vd.n13 0.121712
R11199 vd.n13 vd.n18 9.31565
R11200 vd.n19 vd.n20 11.3247
R11201 vd.n15 vd.n20 23.0789
R11202 vd.n19 vd.n18 27.1064
R11203 vd.n20 vd.n21 77.1778
R11204 vd.n21 vd.n18 184.74
R11205 vd.n21 vd.t4 36.1505
R11206 vtail.n0 vtail.n1 585
R11207 vtail.n3 vtail.n2 13.2471
R11208 vtail.n0 vtail.n3 285.877
R11209 vtail.n6 vtail.n5 13.2471
R11210 vtail.n0 vtail.n6 285.877
R11211 vtail.n9 vtail.n8 13.2471
R11212 vtail.n0 vtail.n9 285.877
R11213 vtail.n11 vtail.n12 13.2471
R11214 vtail.n12 vtail.n0 285.877
R11215 vtail.n14 vtail.n15 13.2471
R11216 vtail.n0 vtail.n15 285.877
R11217 vtail.n17 vtail.n18 13.2471
R11218 vtail.n0 vtail.n18 285.877
R11219 vtail.n20 vtail.n21 13.2471
R11220 vtail.n0 vtail.n21 285.877
R11221 vtail.n23 vtail.n24 13.2471
R11222 vtail.n0 vtail.n24 285.877
R11223 vtail.t14 vtail.n0 7.8805
R11224 vtail.n0 vtail.t15 7.8805
R11225 vtail.n25 vtail.n1 9.3005
R11226 vtail.n26 vtail.n2 9.3005
R11227 vtail.n27 vtail.n4 9.3005
R11228 vtail.n28 vtail.n5 9.3005
R11229 vtail.n29 vtail.n7 9.3005
R11230 vtail.n30 vtail.n8 9.3005
R11231 vtail.n31 vtail.n10 9.3005
R11232 vtail.n32 vtail.n11 9.3005
R11233 vtail.n33 vtail.n13 9.3005
R11234 vtail.n34 vtail.n14 9.3005
R11235 vtail.n35 vtail.n16 9.3005
R11236 vtail.n36 vtail.n17 9.3005
R11237 vtail.n37 vtail.n19 9.3005
R11238 vtail.n38 vtail.n20 9.3005
R11239 vtail.n39 vtail.n22 9.3005
R11240 vtail.n40 vtail.n23 9.3005
R11241 vtail.n1 vtail.n2 27.1064
R11242 vtail.n4 vtail.n3 13.2471
R11243 vtail.n4 vtail.n5 27.1064
R11244 vtail.n7 vtail.n6 13.2471
R11245 vtail.n7 vtail.n8 27.1064
R11246 vtail.n10 vtail.n9 13.2471
R11247 vtail.n10 vtail.n11 27.1064
R11248 vtail.n12 vtail.n13 13.2471
R11249 vtail.n13 vtail.n14 27.1064
R11250 vtail.n15 vtail.n16 13.2471
R11251 vtail.n16 vtail.n17 27.1064
R11252 vtail.n18 vtail.n19 13.2471
R11253 vtail.n19 vtail.n20 27.1064
R11254 vtail.n21 vtail.n22 13.2471
R11255 vtail.n22 vtail.n23 27.1064
R11256 vtail.n25 vtail.n41 4.5005
R11257 vtail.n43 vtail.n44 4.5005
R11258 vtail.n45 vtail.n46 4.5005
R11259 vtail.n47 vtail.n48 4.5005
R11260 vtail.n49 vtail.n50 4.5005
R11261 vtail.n51 vtail.n52 4.5005
R11262 vtail.n53 vtail.n54 4.5005
R11263 vtail.n55 vtail.n56 4.5005
R11264 vtail.n33 vtail.n57 4.5005
R11265 vtail.n58 vtail.n59 4.5005
R11266 vtail.n60 vtail.n61 4.5005
R11267 vtail.n62 vtail.n63 4.5005
R11268 vtail.n64 vtail.n65 4.5005
R11269 vtail.n66 vtail.n67 4.5005
R11270 vtail.n68 vtail.n69 4.5005
R11271 vtail.n70 vtail.n71 4.5005
R11272 vtail.n72 vtail.n616 4.5005
R11273 vtail.n72 vtail.n25 0.1255
R11274 vtail.n26 vtail.n72 0.016125
R11275 vtail.n70 vtail.n26 0.109875
R11276 vtail.n27 vtail.n70 0.03175
R11277 vtail.n68 vtail.n27 0.09425
R11278 vtail.n28 vtail.n68 0.047375
R11279 vtail.n66 vtail.n28 0.078625
R11280 vtail.n29 vtail.n66 0.063
R11281 vtail.n64 vtail.n29 0.063
R11282 vtail.n30 vtail.n64 0.078625
R11283 vtail.n62 vtail.n30 0.047375
R11284 vtail.n31 vtail.n62 0.09425
R11285 vtail.n60 vtail.n31 0.03175
R11286 vtail vtail.n60 0.0766719
R11287 vtail vtail.n32 0.0337031
R11288 vtail.n32 vtail.n58 0.016125
R11289 vtail.n58 vtail.n33 0.1255
R11290 vtail.n33 vtail.n55 0.1255
R11291 vtail.n55 vtail.n34 0.016125
R11292 vtail.n34 vtail.n53 0.109875
R11293 vtail.n53 vtail.n35 0.03175
R11294 vtail.n35 vtail.n51 0.09425
R11295 vtail.n51 vtail.n36 0.047375
R11296 vtail.n36 vtail.n49 0.078625
R11297 vtail.n49 vtail.n37 0.063
R11298 vtail.n37 vtail.n47 0.063
R11299 vtail.n47 vtail.n38 0.078625
R11300 vtail.n38 vtail.n45 0.047375
R11301 vtail.n45 vtail.n39 0.09425
R11302 vtail.n39 vtail.n43 0.03175
R11303 vtail.n43 vtail.n40 0.109875
R11304 vtail.n40 vtail.n42 0.0774358
R11305 vtail.n42 vtail.n24 22.6101
R11306 vtail.n616 vtail.n41 0.1255
R11307 vtail.n616 vtail.n71 0.1255
R11308 vtail.n71 vtail.n69 0.1255
R11309 vtail.n69 vtail.n67 0.1255
R11310 vtail.n67 vtail.n65 0.1255
R11311 vtail.n65 vtail.n63 0.1255
R11312 vtail.n63 vtail.n61 0.1255
R11313 vtail.n61 vtail.n59 0.1255
R11314 vtail.n59 vtail.n57 0.1255
R11315 vtail.n56 vtail.n57 0.1255
R11316 vtail.n54 vtail.n56 0.1255
R11317 vtail.n52 vtail.n54 0.1255
R11318 vtail.n50 vtail.n52 0.1255
R11319 vtail.n48 vtail.n50 0.1255
R11320 vtail.n46 vtail.n48 0.1255
R11321 vtail.n44 vtail.n46 0.1255
R11322 vtail.n42 vtail.n44 2.376
R11323 vtail.n41 vtail.n73 0.32278
R11324 vtail.n539 vtail.n538 4.5005
R11325 vtail.n541 vtail.n540 4.5005
R11326 vtail.n542 vtail.n543 4.5005
R11327 vtail.n544 vtail.n545 4.5005
R11328 vtail.n546 vtail.n547 4.5005
R11329 vtail.n548 vtail.n549 4.5005
R11330 vtail.n550 vtail.n551 4.5005
R11331 vtail.n552 vtail.n553 4.5005
R11332 vtail.n554 vtail.n555 4.5005
R11333 vtail.n556 vtail.n557 4.5005
R11334 vtail.n558 vtail.n559 4.5005
R11335 vtail.n560 vtail.n561 4.5005
R11336 vtail.n562 vtail.n563 4.5005
R11337 vtail.n564 vtail.n565 4.5005
R11338 vtail.n566 vtail.n567 4.5005
R11339 vtail.n568 vtail.n569 4.5005
R11340 vtail.n570 vtail.n571 4.5005
R11341 vtail.n572 vtail.n573 4.5005
R11342 vtail.n573 vtail.n537 2.376
R11343 vtail.n571 vtail.n573 0.1255
R11344 vtail.n569 vtail.n571 0.1255
R11345 vtail.n567 vtail.n569 0.1255
R11346 vtail.n565 vtail.n567 0.1255
R11347 vtail.n563 vtail.n565 0.1255
R11348 vtail.n561 vtail.n563 0.1255
R11349 vtail.n559 vtail.n561 0.1255
R11350 vtail.n557 vtail.n559 0.1255
R11351 vtail.n555 vtail.n557 0.1255
R11352 vtail.n553 vtail.n555 0.1255
R11353 vtail.n551 vtail.n553 0.1255
R11354 vtail.n549 vtail.n551 0.1255
R11355 vtail.n547 vtail.n549 0.1255
R11356 vtail.n545 vtail.n547 0.1255
R11357 vtail.n543 vtail.n545 0.1255
R11358 vtail.n541 vtail.n543 0.1255
R11359 vtail.n539 vtail.n541 0.1255
R11360 vtail.n73 vtail.n539 0.663275
R11361 vtail.n575 vtail.n574 9.3005
R11362 vtail.n577 vtail.n576 9.3005
R11363 vtail.n579 vtail.n578 9.3005
R11364 vtail.n581 vtail.n580 9.3005
R11365 vtail.n583 vtail.n582 9.3005
R11366 vtail.n585 vtail.n584 9.3005
R11367 vtail.n587 vtail.n586 9.3005
R11368 vtail.n589 vtail.n588 9.3005
R11369 vtail.n591 vtail.n590 9.3005
R11370 vtail.n593 vtail.n592 9.3005
R11371 vtail.n595 vtail.n594 9.3005
R11372 vtail.n597 vtail.n596 9.3005
R11373 vtail.n599 vtail.n598 9.3005
R11374 vtail.n601 vtail.n600 9.3005
R11375 vtail.n603 vtail.n602 9.3005
R11376 vtail.n605 vtail.n604 9.3005
R11377 vtail.n614 vtail.n537 22.6179
R11378 vtail.n537 vtail.n575 0.0696233
R11379 vtail.n575 vtail.n572 0.117688
R11380 vtail.n572 vtail.n577 0.0239375
R11381 vtail.n577 vtail.n570 0.102062
R11382 vtail.n570 vtail.n579 0.0395625
R11383 vtail.n579 vtail.n568 0.0864375
R11384 vtail.n568 vtail.n581 0.0551875
R11385 vtail.n581 vtail.n566 0.0708125
R11386 vtail.n566 vtail.n583 0.0708125
R11387 vtail.n583 vtail.n564 0.0551875
R11388 vtail.n564 vtail.n585 0.0864375
R11389 vtail.n585 vtail.n562 0.0395625
R11390 vtail.n562 vtail.n587 0.102062
R11391 vtail.n587 vtail.n560 0.0239375
R11392 vtail.n560 vtail.n589 0.117688
R11393 vtail.n589 vtail.n558 0.0083125
R11394 vtail.n558 vtail 0.03175
R11395 vtail vtail.n556 0.09425
R11396 vtail.n591 vtail.n556 0.0083125
R11397 vtail.n554 vtail.n591 0.117688
R11398 vtail.n593 vtail.n554 0.0239375
R11399 vtail.n552 vtail.n593 0.102062
R11400 vtail.n595 vtail.n552 0.0395625
R11401 vtail.n550 vtail.n595 0.0864375
R11402 vtail.n597 vtail.n550 0.0551875
R11403 vtail.n548 vtail.n597 0.0708125
R11404 vtail.n599 vtail.n548 0.0708125
R11405 vtail.n546 vtail.n599 0.0551875
R11406 vtail.n601 vtail.n546 0.0864375
R11407 vtail.n544 vtail.n601 0.0395625
R11408 vtail.n603 vtail.n544 0.102062
R11409 vtail.n542 vtail.n603 0.0239375
R11410 vtail.n605 vtail.n542 0.117688
R11411 vtail.n540 vtail.n605 0.0083125
R11412 vtail.n540 vtail.n538 0.1255
R11413 vtail.n615 vtail.n614 285.877
R11414 vtail.n574 vtail.n614 13.2471
R11415 vtail.n615 vtail.n613 285.877
R11416 vtail.n613 vtail.n578 13.2471
R11417 vtail.n615 vtail.n612 285.877
R11418 vtail.n612 vtail.n582 13.2471
R11419 vtail.n615 vtail.n611 285.877
R11420 vtail.n611 vtail.n586 13.2471
R11421 vtail.n615 vtail.n610 285.877
R11422 vtail.n610 vtail.n590 13.2471
R11423 vtail.n615 vtail.n609 285.877
R11424 vtail.n594 vtail.n609 13.2471
R11425 vtail.n615 vtail.n608 285.877
R11426 vtail.n598 vtail.n608 13.2471
R11427 vtail.n615 vtail.n607 285.877
R11428 vtail.n602 vtail.n607 13.2471
R11429 vtail.n606 vtail.n615 285.877
R11430 vtail.n538 vtail.n606 22.5549
R11431 vtail.n574 vtail.n576 27.1064
R11432 vtail.n576 vtail.n613 13.2471
R11433 vtail.n578 vtail.n580 27.1064
R11434 vtail.n580 vtail.n612 13.2471
R11435 vtail.n582 vtail.n584 27.1064
R11436 vtail.n584 vtail.n611 13.2471
R11437 vtail.n586 vtail.n588 27.1064
R11438 vtail.n588 vtail.n610 13.2471
R11439 vtail.n590 vtail.n592 27.1064
R11440 vtail.n592 vtail.n609 13.2471
R11441 vtail.n594 vtail.n596 27.1064
R11442 vtail.n596 vtail.n608 13.2471
R11443 vtail.n598 vtail.n600 27.1064
R11444 vtail.n600 vtail.n607 13.2471
R11445 vtail.n602 vtail.n604 27.1064
R11446 vtail.n604 vtail.n606 13.2471
R11447 vtail.n615 vtail.t3 7.57742
R11448 vtail.n615 vtail.t7 7.57742
R11449 vtail.n228 vtail.n227 3.4105
R11450 vtail.n73 vtail.n228 3.87289
R11451 vtail.n383 vtail.n382 3.4105
R11452 vtail.n228 vtail.n383 0.464455
R11453 vtail.n383 vtail.n536 3.8768
R11454 vtail.n459 vtail.n458 4.5005
R11455 vtail.n460 vtail.n461 4.5005
R11456 vtail.n462 vtail.n463 4.5005
R11457 vtail.n464 vtail.n465 4.5005
R11458 vtail.n466 vtail.n467 4.5005
R11459 vtail.n468 vtail.n469 4.5005
R11460 vtail.n470 vtail.n471 4.5005
R11461 vtail.n472 vtail.n473 4.5005
R11462 vtail.n474 vtail.n475 4.5005
R11463 vtail.n476 vtail.n477 4.5005
R11464 vtail.n478 vtail.n479 4.5005
R11465 vtail.n480 vtail.n481 4.5005
R11466 vtail.n482 vtail.n483 4.5005
R11467 vtail.n484 vtail.n485 4.5005
R11468 vtail.n486 vtail.n487 4.5005
R11469 vtail.n488 vtail.n489 4.5005
R11470 vtail.n490 vtail.n491 4.5005
R11471 vtail.n492 vtail.n493 4.5005
R11472 vtail.n493 vtail.n457 2.376
R11473 vtail.n491 vtail.n493 0.1255
R11474 vtail.n489 vtail.n491 0.1255
R11475 vtail.n487 vtail.n489 0.1255
R11476 vtail.n485 vtail.n487 0.1255
R11477 vtail.n483 vtail.n485 0.1255
R11478 vtail.n481 vtail.n483 0.1255
R11479 vtail.n479 vtail.n481 0.1255
R11480 vtail.n477 vtail.n479 0.1255
R11481 vtail.n475 vtail.n477 0.1255
R11482 vtail.n473 vtail.n475 0.1255
R11483 vtail.n471 vtail.n473 0.1255
R11484 vtail.n469 vtail.n471 0.1255
R11485 vtail.n467 vtail.n469 0.1255
R11486 vtail.n465 vtail.n467 0.1255
R11487 vtail.n463 vtail.n465 0.1255
R11488 vtail.n461 vtail.n463 0.1255
R11489 vtail.n459 vtail.n461 0.1255
R11490 vtail.n536 vtail.n459 0.667441
R11491 vtail.n495 vtail.n494 9.3005
R11492 vtail.n497 vtail.n496 9.3005
R11493 vtail.n499 vtail.n498 9.3005
R11494 vtail.n501 vtail.n500 9.3005
R11495 vtail.n503 vtail.n502 9.3005
R11496 vtail.n505 vtail.n504 9.3005
R11497 vtail.n507 vtail.n506 9.3005
R11498 vtail.n509 vtail.n508 9.3005
R11499 vtail.n511 vtail.n510 9.3005
R11500 vtail.n513 vtail.n512 9.3005
R11501 vtail.n515 vtail.n514 9.3005
R11502 vtail.n517 vtail.n516 9.3005
R11503 vtail.n519 vtail.n518 9.3005
R11504 vtail.n521 vtail.n520 9.3005
R11505 vtail.n523 vtail.n522 9.3005
R11506 vtail.n525 vtail.n524 9.3005
R11507 vtail.n534 vtail.n457 22.6179
R11508 vtail.n457 vtail.n495 0.0696233
R11509 vtail.n495 vtail.n492 0.117688
R11510 vtail.n492 vtail.n497 0.0239375
R11511 vtail.n497 vtail.n490 0.102062
R11512 vtail.n490 vtail.n499 0.0395625
R11513 vtail.n499 vtail.n488 0.0864375
R11514 vtail.n488 vtail.n501 0.0551875
R11515 vtail.n501 vtail.n486 0.0708125
R11516 vtail.n486 vtail.n503 0.0708125
R11517 vtail.n503 vtail.n484 0.0551875
R11518 vtail.n484 vtail 0.0532344
R11519 vtail vtail.n505 0.0337031
R11520 vtail.n482 vtail.n505 0.0395625
R11521 vtail.n507 vtail.n482 0.102062
R11522 vtail.n480 vtail.n507 0.0239375
R11523 vtail.n509 vtail.n480 0.117688
R11524 vtail.n478 vtail.n509 0.0083125
R11525 vtail.n476 vtail.n478 0.1255
R11526 vtail.n511 vtail.n476 0.0083125
R11527 vtail.n474 vtail.n511 0.117688
R11528 vtail.n513 vtail.n474 0.0239375
R11529 vtail.n472 vtail.n513 0.102062
R11530 vtail.n515 vtail.n472 0.0395625
R11531 vtail.n470 vtail.n515 0.0864375
R11532 vtail.n517 vtail.n470 0.0551875
R11533 vtail.n468 vtail.n517 0.0708125
R11534 vtail.n519 vtail.n468 0.0708125
R11535 vtail.n466 vtail.n519 0.0551875
R11536 vtail.n521 vtail.n466 0.0864375
R11537 vtail.n464 vtail.n521 0.0395625
R11538 vtail.n523 vtail.n464 0.102062
R11539 vtail.n462 vtail.n523 0.0239375
R11540 vtail.n525 vtail.n462 0.117688
R11541 vtail.n460 vtail.n525 0.0083125
R11542 vtail.n458 vtail.n460 0.1255
R11543 vtail.n535 vtail.n534 285.877
R11544 vtail.n494 vtail.n534 13.2471
R11545 vtail.n535 vtail.n533 285.877
R11546 vtail.n533 vtail.n498 13.2471
R11547 vtail.n535 vtail.n532 285.877
R11548 vtail.n532 vtail.n502 13.2471
R11549 vtail.n535 vtail.n531 285.877
R11550 vtail.n506 vtail.n531 13.2471
R11551 vtail.n535 vtail.n530 285.877
R11552 vtail.n510 vtail.n530 13.2471
R11553 vtail.n535 vtail.n529 285.877
R11554 vtail.n514 vtail.n529 13.2471
R11555 vtail.n535 vtail.n528 285.877
R11556 vtail.n518 vtail.n528 13.2471
R11557 vtail.n535 vtail.n527 285.877
R11558 vtail.n522 vtail.n527 13.2471
R11559 vtail.n526 vtail.n535 285.877
R11560 vtail.n458 vtail.n526 22.5549
R11561 vtail.n494 vtail.n496 27.1064
R11562 vtail.n496 vtail.n533 13.2471
R11563 vtail.n498 vtail.n500 27.1064
R11564 vtail.n500 vtail.n532 13.2471
R11565 vtail.n502 vtail.n504 27.1064
R11566 vtail.n504 vtail.n531 13.2471
R11567 vtail.n506 vtail.n508 27.1064
R11568 vtail.n508 vtail.n530 13.2471
R11569 vtail.n510 vtail.n512 27.1064
R11570 vtail.n512 vtail.n529 13.2471
R11571 vtail.n514 vtail.n516 27.1064
R11572 vtail.n516 vtail.n528 13.2471
R11573 vtail.n518 vtail.n520 27.1064
R11574 vtail.n520 vtail.n527 13.2471
R11575 vtail.n522 vtail.n524 27.1064
R11576 vtail.n524 vtail.n526 13.2471
R11577 vtail.n535 vtail.t4 7.57742
R11578 vtail.n535 vtail.t0 7.57742
R11579 vtail.n386 vtail.n385 4.5005
R11580 vtail.n388 vtail.n387 4.5005
R11581 vtail.n389 vtail.n390 4.5005
R11582 vtail.n391 vtail.n392 4.5005
R11583 vtail.n393 vtail.n394 4.5005
R11584 vtail.n395 vtail.n396 4.5005
R11585 vtail.n397 vtail.n398 4.5005
R11586 vtail.n399 vtail.n400 4.5005
R11587 vtail.n402 vtail.n401 4.5005
R11588 vtail.n403 vtail.n404 4.5005
R11589 vtail.n405 vtail.n406 4.5005
R11590 vtail.n407 vtail.n408 4.5005
R11591 vtail.n409 vtail.n410 4.5005
R11592 vtail.n411 vtail.n412 4.5005
R11593 vtail.n413 vtail.n414 4.5005
R11594 vtail.n415 vtail.n416 4.5005
R11595 vtail.n417 vtail.n418 4.5005
R11596 vtail.n536 vtail.n386 0.318613
R11597 vtail.n386 vtail.n388 0.1255
R11598 vtail.n388 vtail.n390 0.1255
R11599 vtail.n390 vtail.n392 0.1255
R11600 vtail.n392 vtail.n394 0.1255
R11601 vtail.n394 vtail.n396 0.1255
R11602 vtail.n396 vtail.n398 0.1255
R11603 vtail.n398 vtail.n400 0.1255
R11604 vtail.n400 vtail.n402 0.1255
R11605 vtail.n402 vtail.n404 0.1255
R11606 vtail.n404 vtail.n406 0.1255
R11607 vtail.n406 vtail.n408 0.1255
R11608 vtail.n408 vtail.n410 0.1255
R11609 vtail.n410 vtail.n412 0.1255
R11610 vtail.n412 vtail.n414 0.1255
R11611 vtail.n414 vtail.n416 0.1255
R11612 vtail.n416 vtail.n418 0.1255
R11613 vtail.n418 vtail.n384 2.376
R11614 vtail.n420 vtail.n419 9.3005
R11615 vtail.n422 vtail.n421 9.3005
R11616 vtail.n424 vtail.n423 9.3005
R11617 vtail.n426 vtail.n425 9.3005
R11618 vtail.n428 vtail.n427 9.3005
R11619 vtail.n430 vtail.n429 9.3005
R11620 vtail.n432 vtail.n431 9.3005
R11621 vtail.n403 vtail.n433 9.3005
R11622 vtail.n435 vtail.n434 9.3005
R11623 vtail.n437 vtail.n436 9.3005
R11624 vtail.n439 vtail.n438 9.3005
R11625 vtail.n441 vtail.n440 9.3005
R11626 vtail.n443 vtail.n442 9.3005
R11627 vtail.n445 vtail.n444 9.3005
R11628 vtail.n447 vtail.n446 9.3005
R11629 vtail.n385 vtail.n387 0.1255
R11630 vtail.n387 vtail.n447 0.016125
R11631 vtail.n447 vtail.n389 0.109875
R11632 vtail.n389 vtail.n445 0.03175
R11633 vtail.n445 vtail.n391 0.09425
R11634 vtail.n391 vtail.n443 0.047375
R11635 vtail.n443 vtail.n393 0.078625
R11636 vtail.n393 vtail.n441 0.063
R11637 vtail.n441 vtail.n395 0.063
R11638 vtail.n395 vtail.n439 0.078625
R11639 vtail.n439 vtail.n397 0.047375
R11640 vtail.n397 vtail.n437 0.09425
R11641 vtail.n437 vtail.n399 0.03175
R11642 vtail.n399 vtail 0.00245312
R11643 vtail vtail.n435 0.107922
R11644 vtail.n401 vtail.n435 0.016125
R11645 vtail.n401 vtail.n403 0.1255
R11646 vtail.n405 vtail.n403 0.1255
R11647 vtail.n432 vtail.n405 0.016125
R11648 vtail.n407 vtail.n432 0.109875
R11649 vtail.n430 vtail.n407 0.03175
R11650 vtail.n409 vtail.n430 0.09425
R11651 vtail.n428 vtail.n409 0.047375
R11652 vtail.n411 vtail.n428 0.078625
R11653 vtail.n426 vtail.n411 0.063
R11654 vtail.n413 vtail.n426 0.063
R11655 vtail.n424 vtail.n413 0.078625
R11656 vtail.n415 vtail.n424 0.047375
R11657 vtail.n422 vtail.n415 0.09425
R11658 vtail.n417 vtail.n422 0.03175
R11659 vtail.n420 vtail.n417 0.109875
R11660 vtail.n384 vtail.n420 0.0774358
R11661 vtail.n455 vtail.n456 285.877
R11662 vtail.n456 vtail.n454 285.877
R11663 vtail.n454 vtail.n446 13.2471
R11664 vtail.n456 vtail.n453 285.877
R11665 vtail.n453 vtail.n442 13.2471
R11666 vtail.n456 vtail.n452 285.877
R11667 vtail.n452 vtail.n438 13.2471
R11668 vtail.n456 vtail.n451 285.877
R11669 vtail.n451 vtail.n434 13.2471
R11670 vtail.n456 vtail.n450 285.877
R11671 vtail.n431 vtail.n450 13.2471
R11672 vtail.n456 vtail.n449 285.877
R11673 vtail.n427 vtail.n449 13.2471
R11674 vtail.n456 vtail.n448 285.877
R11675 vtail.n423 vtail.n448 13.2471
R11676 vtail.n456 vtail.n421 585
R11677 vtail.n455 vtail.n419 13.2471
R11678 vtail.n385 vtail.n454 22.5471
R11679 vtail.n446 vtail.n444 27.1064
R11680 vtail.n444 vtail.n453 13.2471
R11681 vtail.n442 vtail.n440 27.1064
R11682 vtail.n440 vtail.n452 13.2471
R11683 vtail.n438 vtail.n436 27.1064
R11684 vtail.n436 vtail.n451 13.2471
R11685 vtail.n434 vtail.n433 27.1064
R11686 vtail.n433 vtail.n450 13.2471
R11687 vtail.n431 vtail.n429 27.1064
R11688 vtail.n429 vtail.n449 13.2471
R11689 vtail.n427 vtail.n425 27.1064
R11690 vtail.n425 vtail.n448 13.2471
R11691 vtail.n423 vtail.n421 27.1064
R11692 vtail.n421 vtail.n419 27.1064
R11693 vtail.n384 vtail.n455 22.6101
R11694 vtail.n456 vtail.t8 7.8805
R11695 vtail.n456 vtail.t9 7.8805
R11696 vtail.n305 vtail.n304 4.5005
R11697 vtail.n307 vtail.n306 4.5005
R11698 vtail.n308 vtail.n309 4.5005
R11699 vtail.n310 vtail.n311 4.5005
R11700 vtail.n312 vtail.n313 4.5005
R11701 vtail.n314 vtail.n315 4.5005
R11702 vtail.n316 vtail.n317 4.5005
R11703 vtail.n318 vtail.n319 4.5005
R11704 vtail.n320 vtail.n321 4.5005
R11705 vtail.n322 vtail.n323 4.5005
R11706 vtail.n324 vtail.n325 4.5005
R11707 vtail.n326 vtail.n327 4.5005
R11708 vtail.n328 vtail.n329 4.5005
R11709 vtail.n330 vtail.n331 4.5005
R11710 vtail.n332 vtail.n333 4.5005
R11711 vtail.n334 vtail.n335 4.5005
R11712 vtail.n336 vtail.n337 4.5005
R11713 vtail.n338 vtail.n339 4.5005
R11714 vtail.n339 vtail.n303 2.376
R11715 vtail.n337 vtail.n339 0.1255
R11716 vtail.n335 vtail.n337 0.1255
R11717 vtail.n333 vtail.n335 0.1255
R11718 vtail.n331 vtail.n333 0.1255
R11719 vtail.n329 vtail.n331 0.1255
R11720 vtail.n327 vtail.n329 0.1255
R11721 vtail.n325 vtail.n327 0.1255
R11722 vtail.n323 vtail.n325 0.1255
R11723 vtail.n321 vtail.n323 0.1255
R11724 vtail.n319 vtail.n321 0.1255
R11725 vtail.n317 vtail.n319 0.1255
R11726 vtail.n315 vtail.n317 0.1255
R11727 vtail.n313 vtail.n315 0.1255
R11728 vtail.n311 vtail.n313 0.1255
R11729 vtail.n309 vtail.n311 0.1255
R11730 vtail.n307 vtail.n309 0.1255
R11731 vtail.n305 vtail.n307 0.1255
R11732 vtail.n382 vtail.n305 0.667441
R11733 vtail.n341 vtail.n340 9.3005
R11734 vtail.n343 vtail.n342 9.3005
R11735 vtail.n345 vtail.n344 9.3005
R11736 vtail.n347 vtail.n346 9.3005
R11737 vtail.n349 vtail.n348 9.3005
R11738 vtail.n351 vtail.n350 9.3005
R11739 vtail.n353 vtail.n352 9.3005
R11740 vtail.n355 vtail.n354 9.3005
R11741 vtail.n357 vtail.n356 9.3005
R11742 vtail.n359 vtail.n358 9.3005
R11743 vtail.n361 vtail.n360 9.3005
R11744 vtail.n363 vtail.n362 9.3005
R11745 vtail.n365 vtail.n364 9.3005
R11746 vtail.n367 vtail.n366 9.3005
R11747 vtail.n369 vtail.n368 9.3005
R11748 vtail.n371 vtail.n370 9.3005
R11749 vtail.n380 vtail.n303 22.6179
R11750 vtail.n303 vtail.n341 0.0696233
R11751 vtail.n341 vtail.n338 0.117688
R11752 vtail.n338 vtail.n343 0.0239375
R11753 vtail.n343 vtail.n336 0.102062
R11754 vtail.n336 vtail.n345 0.0395625
R11755 vtail.n345 vtail.n334 0.0864375
R11756 vtail.n334 vtail.n347 0.0551875
R11757 vtail.n347 vtail.n332 0.0708125
R11758 vtail.n332 vtail.n349 0.0708125
R11759 vtail.n349 vtail.n330 0.0551875
R11760 vtail.n330 vtail.n351 0.0864375
R11761 vtail.n351 vtail.n328 0.0395625
R11762 vtail.n328 vtail.n353 0.102062
R11763 vtail.n353 vtail.n326 0.0239375
R11764 vtail.n326 vtail 0.0825312
R11765 vtail vtail.n355 0.0356562
R11766 vtail.n324 vtail.n355 0.0083125
R11767 vtail.n322 vtail.n324 0.1255
R11768 vtail.n357 vtail.n322 0.0083125
R11769 vtail.n320 vtail.n357 0.117688
R11770 vtail.n359 vtail.n320 0.0239375
R11771 vtail.n318 vtail.n359 0.102062
R11772 vtail.n361 vtail.n318 0.0395625
R11773 vtail.n316 vtail.n361 0.0864375
R11774 vtail.n363 vtail.n316 0.0551875
R11775 vtail.n314 vtail.n363 0.0708125
R11776 vtail.n365 vtail.n314 0.0708125
R11777 vtail.n312 vtail.n365 0.0551875
R11778 vtail.n367 vtail.n312 0.0864375
R11779 vtail.n310 vtail.n367 0.0395625
R11780 vtail.n369 vtail.n310 0.102062
R11781 vtail.n308 vtail.n369 0.0239375
R11782 vtail.n371 vtail.n308 0.117688
R11783 vtail.n306 vtail.n371 0.0083125
R11784 vtail.n306 vtail.n304 0.1255
R11785 vtail.n381 vtail.n380 285.877
R11786 vtail.n340 vtail.n380 13.2471
R11787 vtail.n381 vtail.n379 285.877
R11788 vtail.n379 vtail.n344 13.2471
R11789 vtail.n381 vtail.n378 285.877
R11790 vtail.n378 vtail.n348 13.2471
R11791 vtail.n381 vtail.n377 285.877
R11792 vtail.n377 vtail.n352 13.2471
R11793 vtail.n381 vtail.n376 285.877
R11794 vtail.n356 vtail.n376 13.2471
R11795 vtail.n381 vtail.n375 285.877
R11796 vtail.n360 vtail.n375 13.2471
R11797 vtail.n381 vtail.n374 285.877
R11798 vtail.n364 vtail.n374 13.2471
R11799 vtail.n381 vtail.n373 285.877
R11800 vtail.n368 vtail.n373 13.2471
R11801 vtail.n372 vtail.n381 285.877
R11802 vtail.n304 vtail.n372 22.5549
R11803 vtail.n340 vtail.n342 27.1064
R11804 vtail.n342 vtail.n379 13.2471
R11805 vtail.n344 vtail.n346 27.1064
R11806 vtail.n346 vtail.n378 13.2471
R11807 vtail.n348 vtail.n350 27.1064
R11808 vtail.n350 vtail.n377 13.2471
R11809 vtail.n352 vtail.n354 27.1064
R11810 vtail.n354 vtail.n376 13.2471
R11811 vtail.n356 vtail.n358 27.1064
R11812 vtail.n358 vtail.n375 13.2471
R11813 vtail.n360 vtail.n362 27.1064
R11814 vtail.n362 vtail.n374 13.2471
R11815 vtail.n364 vtail.n366 27.1064
R11816 vtail.n366 vtail.n373 13.2471
R11817 vtail.n368 vtail.n370 27.1064
R11818 vtail.n370 vtail.n372 13.2471
R11819 vtail.n381 vtail.t1 7.57742
R11820 vtail.n381 vtail.t5 7.57742
R11821 vtail.n230 vtail.n229 4.5005
R11822 vtail.n232 vtail.n233 4.5005
R11823 vtail.n234 vtail.n235 4.5005
R11824 vtail.n236 vtail.n237 4.5005
R11825 vtail.n238 vtail.n239 4.5005
R11826 vtail.n240 vtail.n241 4.5005
R11827 vtail.n242 vtail.n243 4.5005
R11828 vtail.n244 vtail.n245 4.5005
R11829 vtail.n246 vtail.n247 4.5005
R11830 vtail.n249 vtail.n248 4.5005
R11831 vtail.n250 vtail.n251 4.5005
R11832 vtail.n252 vtail.n253 4.5005
R11833 vtail.n254 vtail.n255 4.5005
R11834 vtail.n256 vtail.n257 4.5005
R11835 vtail.n258 vtail.n259 4.5005
R11836 vtail.n260 vtail.n261 4.5005
R11837 vtail.n301 vtail.n302 4.5005
R11838 vtail.n382 vtail.n230 0.318613
R11839 vtail.n230 vtail.n302 0.1255
R11840 vtail.n302 vtail.n261 0.1255
R11841 vtail.n261 vtail.n259 0.1255
R11842 vtail.n259 vtail.n257 0.1255
R11843 vtail.n257 vtail.n255 0.1255
R11844 vtail.n255 vtail.n253 0.1255
R11845 vtail.n253 vtail.n251 0.1255
R11846 vtail.n251 vtail.n249 0.1255
R11847 vtail.n249 vtail.n247 0.1255
R11848 vtail.n247 vtail.n245 0.1255
R11849 vtail.n245 vtail.n243 0.1255
R11850 vtail.n243 vtail.n241 0.1255
R11851 vtail.n241 vtail.n239 0.1255
R11852 vtail.n239 vtail.n237 0.1255
R11853 vtail.n237 vtail.n235 0.1255
R11854 vtail.n235 vtail.n233 0.1255
R11855 vtail.n233 vtail.n231 2.376
R11856 vtail.n263 vtail.n262 9.3005
R11857 vtail.n265 vtail.n264 9.3005
R11858 vtail.n267 vtail.n266 9.3005
R11859 vtail.n269 vtail.n268 9.3005
R11860 vtail.n271 vtail.n270 9.3005
R11861 vtail.n273 vtail.n272 9.3005
R11862 vtail.n275 vtail.n274 9.3005
R11863 vtail.n246 vtail.n276 9.3005
R11864 vtail.n278 vtail.n277 9.3005
R11865 vtail.n280 vtail.n279 9.3005
R11866 vtail.n282 vtail.n281 9.3005
R11867 vtail.n284 vtail.n283 9.3005
R11868 vtail.n286 vtail.n285 9.3005
R11869 vtail.n288 vtail.n287 9.3005
R11870 vtail.n290 vtail.n289 9.3005
R11871 vtail.n231 vtail.n291 9.3635
R11872 vtail.n229 vtail.n301 0.1255
R11873 vtail.n301 vtail.n263 0.016125
R11874 vtail.n263 vtail.n260 0.109875
R11875 vtail.n260 vtail.n265 0.03175
R11876 vtail.n265 vtail.n258 0.09425
R11877 vtail.n258 vtail.n267 0.047375
R11878 vtail.n267 vtail.n256 0.078625
R11879 vtail.n256 vtail.n269 0.063
R11880 vtail.n269 vtail.n254 0.063
R11881 vtail.n254 vtail.n271 0.078625
R11882 vtail.n271 vtail.n252 0.047375
R11883 vtail.n252 vtail.n273 0.09425
R11884 vtail.n273 vtail.n250 0.03175
R11885 vtail.n250 vtail 0.0766719
R11886 vtail vtail.n275 0.0337031
R11887 vtail.n248 vtail.n275 0.016125
R11888 vtail.n248 vtail.n246 0.1255
R11889 vtail.n244 vtail.n246 0.1255
R11890 vtail.n278 vtail.n244 0.016125
R11891 vtail.n242 vtail.n278 0.109875
R11892 vtail.n280 vtail.n242 0.03175
R11893 vtail.n240 vtail.n280 0.09425
R11894 vtail.n282 vtail.n240 0.047375
R11895 vtail.n238 vtail.n282 0.078625
R11896 vtail.n284 vtail.n238 0.063
R11897 vtail.n236 vtail.n284 0.063
R11898 vtail.n286 vtail.n236 0.078625
R11899 vtail.n234 vtail.n286 0.047375
R11900 vtail.n288 vtail.n234 0.09425
R11901 vtail.n232 vtail.n288 0.03175
R11902 vtail.n290 vtail.n232 0.109875
R11903 vtail.n231 vtail.n290 0.0774358
R11904 vtail.n300 vtail.n299 285.877
R11905 vtail.n299 vtail.n262 13.2471
R11906 vtail.n300 vtail.n298 285.877
R11907 vtail.n298 vtail.n266 13.2471
R11908 vtail.n300 vtail.n297 285.877
R11909 vtail.n297 vtail.n270 13.2471
R11910 vtail.n300 vtail.n296 285.877
R11911 vtail.n296 vtail.n274 13.2471
R11912 vtail.n300 vtail.n295 285.877
R11913 vtail.n277 vtail.n295 13.2471
R11914 vtail.n300 vtail.n294 285.877
R11915 vtail.n281 vtail.n294 13.2471
R11916 vtail.n300 vtail.n293 285.877
R11917 vtail.n285 vtail.n293 13.2471
R11918 vtail.n292 vtail.n300 285.877
R11919 vtail.n289 vtail.n292 13.2471
R11920 vtail.n300 vtail.n291 585
R11921 vtail.n229 vtail.n299 22.5471
R11922 vtail.n262 vtail.n264 27.1064
R11923 vtail.n264 vtail.n298 13.2471
R11924 vtail.n266 vtail.n268 27.1064
R11925 vtail.n268 vtail.n297 13.2471
R11926 vtail.n270 vtail.n272 27.1064
R11927 vtail.n272 vtail.n296 13.2471
R11928 vtail.n274 vtail.n276 27.1064
R11929 vtail.n276 vtail.n295 13.2471
R11930 vtail.n277 vtail.n279 27.1064
R11931 vtail.n279 vtail.n294 13.2471
R11932 vtail.n281 vtail.n283 27.1064
R11933 vtail.n283 vtail.n293 13.2471
R11934 vtail.n285 vtail.n287 27.1064
R11935 vtail.n287 vtail.n292 13.2471
R11936 vtail.n289 vtail.n291 27.1064
R11937 vtail.n300 vtail.t10 7.8805
R11938 vtail.n300 vtail.t11 7.8805
R11939 vtail.n150 vtail.n149 4.5005
R11940 vtail.n151 vtail.n152 4.5005
R11941 vtail.n153 vtail.n154 4.5005
R11942 vtail.n155 vtail.n156 4.5005
R11943 vtail.n157 vtail.n158 4.5005
R11944 vtail.n159 vtail.n160 4.5005
R11945 vtail.n161 vtail.n162 4.5005
R11946 vtail.n163 vtail.n164 4.5005
R11947 vtail.n165 vtail.n166 4.5005
R11948 vtail.n167 vtail.n168 4.5005
R11949 vtail.n169 vtail.n170 4.5005
R11950 vtail.n171 vtail.n172 4.5005
R11951 vtail.n173 vtail.n174 4.5005
R11952 vtail.n175 vtail.n176 4.5005
R11953 vtail.n177 vtail.n178 4.5005
R11954 vtail.n179 vtail.n180 4.5005
R11955 vtail.n181 vtail.n182 4.5005
R11956 vtail.n183 vtail.n184 4.5005
R11957 vtail.n184 vtail.n148 2.376
R11958 vtail.n182 vtail.n184 0.1255
R11959 vtail.n180 vtail.n182 0.1255
R11960 vtail.n178 vtail.n180 0.1255
R11961 vtail.n176 vtail.n178 0.1255
R11962 vtail.n174 vtail.n176 0.1255
R11963 vtail.n172 vtail.n174 0.1255
R11964 vtail.n170 vtail.n172 0.1255
R11965 vtail.n168 vtail.n170 0.1255
R11966 vtail.n166 vtail.n168 0.1255
R11967 vtail.n164 vtail.n166 0.1255
R11968 vtail.n162 vtail.n164 0.1255
R11969 vtail.n160 vtail.n162 0.1255
R11970 vtail.n158 vtail.n160 0.1255
R11971 vtail.n156 vtail.n158 0.1255
R11972 vtail.n154 vtail.n156 0.1255
R11973 vtail.n152 vtail.n154 0.1255
R11974 vtail.n150 vtail.n152 0.1255
R11975 vtail.n227 vtail.n150 0.675774
R11976 vtail.n186 vtail.n185 9.3005
R11977 vtail.n188 vtail.n187 9.3005
R11978 vtail.n190 vtail.n189 9.3005
R11979 vtail.n192 vtail.n191 9.3005
R11980 vtail.n194 vtail.n193 9.3005
R11981 vtail.n196 vtail.n195 9.3005
R11982 vtail.n198 vtail.n197 9.3005
R11983 vtail.n200 vtail.n199 9.3005
R11984 vtail.n202 vtail.n201 9.3005
R11985 vtail.n204 vtail.n203 9.3005
R11986 vtail.n206 vtail.n205 9.3005
R11987 vtail.n208 vtail.n207 9.3005
R11988 vtail.n210 vtail.n209 9.3005
R11989 vtail.n212 vtail.n211 9.3005
R11990 vtail.n214 vtail.n213 9.3005
R11991 vtail.n216 vtail.n215 9.3005
R11992 vtail.n225 vtail.n148 22.6179
R11993 vtail.n148 vtail.n186 0.0696233
R11994 vtail.n186 vtail.n183 0.117688
R11995 vtail.n183 vtail.n188 0.0239375
R11996 vtail.n188 vtail.n181 0.102062
R11997 vtail.n181 vtail.n190 0.0395625
R11998 vtail.n190 vtail.n179 0.0864375
R11999 vtail.n179 vtail.n192 0.0551875
R12000 vtail.n192 vtail.n177 0.0708125
R12001 vtail.n177 vtail.n194 0.0708125
R12002 vtail.n194 vtail.n175 0.0551875
R12003 vtail.n175 vtail.n196 0.0864375
R12004 vtail.n196 vtail.n173 0.0395625
R12005 vtail.n173 vtail.n198 0.102062
R12006 vtail.n198 vtail.n171 0.0239375
R12007 vtail.n171 vtail 0.0102656
R12008 vtail vtail.n200 0.107922
R12009 vtail.n169 vtail.n200 0.0083125
R12010 vtail.n167 vtail.n169 0.1255
R12011 vtail.n202 vtail.n167 0.0083125
R12012 vtail.n165 vtail.n202 0.117688
R12013 vtail.n204 vtail.n165 0.0239375
R12014 vtail.n163 vtail.n204 0.102062
R12015 vtail.n206 vtail.n163 0.0395625
R12016 vtail.n161 vtail.n206 0.0864375
R12017 vtail.n208 vtail.n161 0.0551875
R12018 vtail.n159 vtail.n208 0.0708125
R12019 vtail.n210 vtail.n159 0.0708125
R12020 vtail.n157 vtail.n210 0.0551875
R12021 vtail.n212 vtail.n157 0.0864375
R12022 vtail.n155 vtail.n212 0.0395625
R12023 vtail.n214 vtail.n155 0.102062
R12024 vtail.n153 vtail.n214 0.0239375
R12025 vtail.n216 vtail.n153 0.117688
R12026 vtail.n151 vtail.n216 0.0083125
R12027 vtail.n149 vtail.n151 0.1255
R12028 vtail.n226 vtail.n225 285.877
R12029 vtail.n185 vtail.n225 13.2471
R12030 vtail.n226 vtail.n224 285.877
R12031 vtail.n224 vtail.n189 13.2471
R12032 vtail.n226 vtail.n223 285.877
R12033 vtail.n223 vtail.n193 13.2471
R12034 vtail.n226 vtail.n222 285.877
R12035 vtail.n222 vtail.n197 13.2471
R12036 vtail.n226 vtail.n221 285.877
R12037 vtail.n201 vtail.n221 13.2471
R12038 vtail.n226 vtail.n220 285.877
R12039 vtail.n205 vtail.n220 13.2471
R12040 vtail.n226 vtail.n219 285.877
R12041 vtail.n209 vtail.n219 13.2471
R12042 vtail.n226 vtail.n218 285.877
R12043 vtail.n213 vtail.n218 13.2471
R12044 vtail.n217 vtail.n226 285.877
R12045 vtail.n149 vtail.n217 22.5549
R12046 vtail.n185 vtail.n187 27.1064
R12047 vtail.n187 vtail.n224 13.2471
R12048 vtail.n189 vtail.n191 27.1064
R12049 vtail.n191 vtail.n223 13.2471
R12050 vtail.n193 vtail.n195 27.1064
R12051 vtail.n195 vtail.n222 13.2471
R12052 vtail.n197 vtail.n199 27.1064
R12053 vtail.n199 vtail.n221 13.2471
R12054 vtail.n201 vtail.n203 27.1064
R12055 vtail.n203 vtail.n220 13.2471
R12056 vtail.n205 vtail.n207 27.1064
R12057 vtail.n207 vtail.n219 13.2471
R12058 vtail.n209 vtail.n211 27.1064
R12059 vtail.n211 vtail.n218 13.2471
R12060 vtail.n213 vtail.n215 27.1064
R12061 vtail.n215 vtail.n217 13.2471
R12062 vtail.n226 vtail.t6 7.57742
R12063 vtail.n226 vtail.t2 7.57742
R12064 vtail.n75 vtail.n74 4.5005
R12065 vtail.n77 vtail.n78 4.5005
R12066 vtail.n79 vtail.n80 4.5005
R12067 vtail.n81 vtail.n82 4.5005
R12068 vtail.n83 vtail.n84 4.5005
R12069 vtail.n85 vtail.n86 4.5005
R12070 vtail.n87 vtail.n88 4.5005
R12071 vtail.n89 vtail.n90 4.5005
R12072 vtail.n91 vtail.n92 4.5005
R12073 vtail.n94 vtail.n93 4.5005
R12074 vtail.n95 vtail.n96 4.5005
R12075 vtail.n97 vtail.n98 4.5005
R12076 vtail.n99 vtail.n100 4.5005
R12077 vtail.n101 vtail.n102 4.5005
R12078 vtail.n103 vtail.n104 4.5005
R12079 vtail.n105 vtail.n106 4.5005
R12080 vtail.n146 vtail.n147 4.5005
R12081 vtail.n227 vtail.n75 0.31028
R12082 vtail.n75 vtail.n147 0.1255
R12083 vtail.n147 vtail.n106 0.1255
R12084 vtail.n106 vtail.n104 0.1255
R12085 vtail.n104 vtail.n102 0.1255
R12086 vtail.n102 vtail.n100 0.1255
R12087 vtail.n100 vtail.n98 0.1255
R12088 vtail.n98 vtail.n96 0.1255
R12089 vtail.n96 vtail.n94 0.1255
R12090 vtail.n94 vtail.n92 0.1255
R12091 vtail.n92 vtail.n90 0.1255
R12092 vtail.n90 vtail.n88 0.1255
R12093 vtail.n88 vtail.n86 0.1255
R12094 vtail.n86 vtail.n84 0.1255
R12095 vtail.n84 vtail.n82 0.1255
R12096 vtail.n82 vtail.n80 0.1255
R12097 vtail.n80 vtail.n78 0.1255
R12098 vtail.n78 vtail.n76 2.376
R12099 vtail.n108 vtail.n107 9.3005
R12100 vtail.n110 vtail.n109 9.3005
R12101 vtail.n112 vtail.n111 9.3005
R12102 vtail.n114 vtail.n113 9.3005
R12103 vtail.n116 vtail.n115 9.3005
R12104 vtail.n118 vtail.n117 9.3005
R12105 vtail.n120 vtail.n119 9.3005
R12106 vtail.n91 vtail.n121 9.3005
R12107 vtail.n123 vtail.n122 9.3005
R12108 vtail.n125 vtail.n124 9.3005
R12109 vtail.n127 vtail.n126 9.3005
R12110 vtail.n129 vtail.n128 9.3005
R12111 vtail.n131 vtail.n130 9.3005
R12112 vtail.n133 vtail.n132 9.3005
R12113 vtail.n135 vtail.n134 9.3005
R12114 vtail.n76 vtail.n136 9.3635
R12115 vtail.n74 vtail.n146 0.1255
R12116 vtail.n146 vtail.n108 0.016125
R12117 vtail.n108 vtail.n105 0.109875
R12118 vtail.n105 vtail.n110 0.03175
R12119 vtail.n110 vtail.n103 0.09425
R12120 vtail.n103 vtail.n112 0.047375
R12121 vtail.n112 vtail.n101 0.078625
R12122 vtail.n101 vtail.n114 0.063
R12123 vtail.n114 vtail.n99 0.063
R12124 vtail.n99 vtail.n116 0.078625
R12125 vtail.n116 vtail.n97 0.047375
R12126 vtail.n97 vtail.n118 0.09425
R12127 vtail.n118 vtail.n95 0.03175
R12128 vtail.n95 vtail 0.00245312
R12129 vtail vtail.n120 0.107922
R12130 vtail.n93 vtail.n120 0.016125
R12131 vtail.n93 vtail.n91 0.1255
R12132 vtail.n89 vtail.n91 0.1255
R12133 vtail.n123 vtail.n89 0.016125
R12134 vtail.n87 vtail.n123 0.109875
R12135 vtail.n125 vtail.n87 0.03175
R12136 vtail.n85 vtail.n125 0.09425
R12137 vtail.n127 vtail.n85 0.047375
R12138 vtail.n83 vtail.n127 0.078625
R12139 vtail.n129 vtail.n83 0.063
R12140 vtail.n81 vtail.n129 0.063
R12141 vtail.n131 vtail.n81 0.078625
R12142 vtail.n79 vtail.n131 0.047375
R12143 vtail.n133 vtail.n79 0.09425
R12144 vtail.n77 vtail.n133 0.03175
R12145 vtail.n135 vtail.n77 0.109875
R12146 vtail.n76 vtail.n135 0.0774358
R12147 vtail.n145 vtail.n144 285.877
R12148 vtail.n144 vtail.n107 13.2471
R12149 vtail.n145 vtail.n143 285.877
R12150 vtail.n143 vtail.n111 13.2471
R12151 vtail.n145 vtail.n142 285.877
R12152 vtail.n142 vtail.n115 13.2471
R12153 vtail.n145 vtail.n141 285.877
R12154 vtail.n141 vtail.n119 13.2471
R12155 vtail.n145 vtail.n140 285.877
R12156 vtail.n122 vtail.n140 13.2471
R12157 vtail.n145 vtail.n139 285.877
R12158 vtail.n126 vtail.n139 13.2471
R12159 vtail.n145 vtail.n138 285.877
R12160 vtail.n130 vtail.n138 13.2471
R12161 vtail.n137 vtail.n145 285.877
R12162 vtail.n134 vtail.n137 13.2471
R12163 vtail.n145 vtail.n136 585
R12164 vtail.n74 vtail.n144 22.5471
R12165 vtail.n107 vtail.n109 27.1064
R12166 vtail.n109 vtail.n143 13.2471
R12167 vtail.n111 vtail.n113 27.1064
R12168 vtail.n113 vtail.n142 13.2471
R12169 vtail.n115 vtail.n117 27.1064
R12170 vtail.n117 vtail.n141 13.2471
R12171 vtail.n119 vtail.n121 27.1064
R12172 vtail.n121 vtail.n140 13.2471
R12173 vtail.n122 vtail.n124 27.1064
R12174 vtail.n124 vtail.n139 13.2471
R12175 vtail.n126 vtail.n128 27.1064
R12176 vtail.n128 vtail.n138 13.2471
R12177 vtail.n130 vtail.n132 27.1064
R12178 vtail.n132 vtail.n137 13.2471
R12179 vtail.n134 vtail.n136 27.1064
R12180 vtail.n145 vtail.t12 7.8805
R12181 vtail.n145 vtail.t13 7.8805
C0 vgp vo1 0.21656f
C1 vmiler VIN_ota 0.01706f
C2 VO_ota vd 0.23307f
C3 vgp VIP_ota 0.04013f
C4 VGN vd 0.01014f
C5 VIN_ota vtail 1.61555f
C6 vmiler vd 0.08476f
C7 VDD vo1 1.07231f
C8 VIN_ota vd 2.44718f
C9 VDD VIP_ota 1.66005f
C10 VO_ota vo1 0.77987f
C11 vtail vd 2.68973f
C12 vmiler vo1 0.05207f
C13 vgp VDD 28.2885f
C14 vmiler VIP_ota 0.01136f
C15 VIN_ota vo1 0.40541f
C16 vtail vo1 2.7773f
C17 vgp VO_ota 4.70399f
C18 VIN_ota VIP_ota 1.23149f
C19 VIP_ota vtail 1.66179f
C20 vd vo1 1.45449f
C21 vgp VGN 0.53844f
C22 VIP_ota vd 0.78032f
C23 VDD VO_ota 6.02411f
C24 vgp VIN_ota 0.04119f
C25 vgp vtail 3.34725f
C26 VDD VGN 0.02981f
C27 vmiler VDD 0.03607f
C28 vgp vd 0.14213f
C29 VIP_ota vo1 2.05974f
C30 VDD VIN_ota 2.30973f
C31 VO_ota VGN 0.01533f
C32 vmiler VO_ota 0.18162p
C33 VDD vtail 8.52176f
C34 VO_ota VIN_ota 0.01396f
C35 vmiler VGN 0.01539f
C36 VDD vd 2.43387f
C37 VIP_ota VSS 0.30277f
C38 VIN_ota VSS 0.7621f
C39 VGN VSS 2.45218f
C40 VO_ota VSS 37.61751f
C41 VDD VSS 77.64548f
C42 vgp VSS 2.77689f
C43 vmiler VSS 6.57282f
C44 vo1 VSS 14.25453f
C45 vd VSS 8.51317f
C46 vtail VSS 0.35815f
C47 vtail.t14 VSS 0.22373f
C48 vtail.n0 VSS 0.44745f
C49 vtail.n1 VSS 0.0168f
C50 vtail.n2 VSS 0.01753f
C51 vtail.n4 VSS 0.01753f
C52 vtail.n5 VSS 0.01753f
C53 vtail.n7 VSS 0.01753f
C54 vtail.n8 VSS 0.01753f
C55 vtail.n10 VSS 0.01753f
C56 vtail.n11 VSS 0.01753f
C57 vtail.n13 VSS 0.01753f
C58 vtail.n14 VSS 0.01753f
C59 vtail.n16 VSS 0.01753f
C60 vtail.n17 VSS 0.01753f
C61 vtail.n19 VSS 0.01753f
C62 vtail.n20 VSS 0.01753f
C63 vtail.n22 VSS 0.01753f
C64 vtail.n23 VSS 0.01753f
C65 vtail.n25 VSS 0.03711f
C66 vtail.n26 VSS 0.01466f
C67 vtail.n27 VSS 0.01466f
C68 vtail.n28 VSS 0.01466f
C69 vtail.n29 VSS 0.01466f
C70 vtail.n30 VSS 0.01466f
C71 vtail.n31 VSS 0.01466f
C72 vtail.n33 VSS 0.02932f
C73 vtail.n34 VSS 0.01466f
C74 vtail.n35 VSS 0.01466f
C75 vtail.n36 VSS 0.01466f
C76 vtail.n37 VSS 0.01466f
C77 vtail.n38 VSS 0.01466f
C78 vtail.n39 VSS 0.01466f
C79 vtail.n40 VSS 0.02781f
C80 vtail.n41 VSS 0.05072f
C81 vtail.n42 VSS 0.05464f
C82 vtail.n43 VSS 0.01649f
C83 vtail.n44 VSS 0.09132f
C84 vtail.n45 VSS 0.01649f
C85 vtail.n46 VSS 0.02932f
C86 vtail.n47 VSS 0.01649f
C87 vtail.n48 VSS 0.02932f
C88 vtail.n49 VSS 0.01649f
C89 vtail.n50 VSS 0.02932f
C90 vtail.n51 VSS 0.01649f
C91 vtail.n52 VSS 0.02932f
C92 vtail.n53 VSS 0.01649f
C93 vtail.n54 VSS 0.02932f
C94 vtail.n55 VSS 0.01649f
C95 vtail.n56 VSS 0.02932f
C96 vtail.n57 VSS 0.02932f
C97 vtail.n58 VSS 0.01649f
C98 vtail.n59 VSS 0.02932f
C99 vtail.n60 VSS 0.0126f
C100 vtail.n61 VSS 0.02932f
C101 vtail.n62 VSS 0.01649f
C102 vtail.n63 VSS 0.02932f
C103 vtail.n64 VSS 0.01649f
C104 vtail.n65 VSS 0.02932f
C105 vtail.n66 VSS 0.01649f
C106 vtail.n67 VSS 0.02932f
C107 vtail.n68 VSS 0.01649f
C108 vtail.n69 VSS 0.02932f
C109 vtail.n70 VSS 0.01649f
C110 vtail.n71 VSS 0.02932f
C111 vtail.n72 VSS 0.01649f
C112 vtail.n73 VSS 0.1309f
C113 vtail.n74 VSS 0.04698f
C114 vtail.n75 VSS 0.04944f
C115 vtail.n76 VSS 0.04465f
C116 vtail.n77 VSS 0.01649f
C117 vtail.n78 VSS 0.09132f
C118 vtail.n79 VSS 0.01649f
C119 vtail.n80 VSS 0.02932f
C120 vtail.n81 VSS 0.01649f
C121 vtail.n82 VSS 0.02932f
C122 vtail.n83 VSS 0.01649f
C123 vtail.n84 VSS 0.02932f
C124 vtail.n85 VSS 0.01649f
C125 vtail.n86 VSS 0.02932f
C126 vtail.n87 VSS 0.01649f
C127 vtail.n88 VSS 0.02932f
C128 vtail.n89 VSS 0.01649f
C129 vtail.n90 VSS 0.02932f
C130 vtail.n91 VSS 0.02932f
C131 vtail.n92 VSS 0.02932f
C132 vtail.n93 VSS 0.01649f
C133 vtail.n94 VSS 0.02932f
C134 vtail.n96 VSS 0.02932f
C135 vtail.n97 VSS 0.01649f
C136 vtail.n98 VSS 0.02932f
C137 vtail.n99 VSS 0.01649f
C138 vtail.n100 VSS 0.02932f
C139 vtail.n101 VSS 0.01649f
C140 vtail.n102 VSS 0.02932f
C141 vtail.n103 VSS 0.01649f
C142 vtail.n104 VSS 0.02932f
C143 vtail.n105 VSS 0.01649f
C144 vtail.n106 VSS 0.02932f
C145 vtail.n107 VSS 0.01753f
C146 vtail.n108 VSS 0.01466f
C147 vtail.n109 VSS 0.01753f
C148 vtail.n110 VSS 0.01466f
C149 vtail.n111 VSS 0.01753f
C150 vtail.n112 VSS 0.01466f
C151 vtail.n113 VSS 0.01753f
C152 vtail.n114 VSS 0.01466f
C153 vtail.n115 VSS 0.01753f
C154 vtail.n116 VSS 0.01466f
C155 vtail.n117 VSS 0.01753f
C156 vtail.n118 VSS 0.01466f
C157 vtail.n119 VSS 0.01753f
C158 vtail.n120 VSS 0.01443f
C159 vtail.n121 VSS 0.01753f
C160 vtail.n122 VSS 0.01753f
C161 vtail.n123 VSS 0.01466f
C162 vtail.n124 VSS 0.01753f
C163 vtail.n125 VSS 0.01466f
C164 vtail.n126 VSS 0.01753f
C165 vtail.n127 VSS 0.01466f
C166 vtail.n128 VSS 0.01753f
C167 vtail.n129 VSS 0.01466f
C168 vtail.n130 VSS 0.01753f
C169 vtail.n131 VSS 0.01466f
C170 vtail.n132 VSS 0.01753f
C171 vtail.n133 VSS 0.01466f
C172 vtail.n134 VSS 0.01753f
C173 vtail.n135 VSS 0.02781f
C174 vtail.n136 VSS 0.01705f
C175 vtail.n145 VSS 0.44745f
C176 vtail.t12 VSS 0.22373f
C177 vtail.t13 VSS 0.22373f
C178 vtail.n146 VSS 0.01649f
C179 vtail.n147 VSS 0.02932f
C180 vtail.n148 VSS 0.0496f
C181 vtail.n149 VSS 0.04376f
C182 vtail.n150 VSS 0.08671f
C183 vtail.n151 VSS 0.01558f
C184 vtail.n152 VSS 0.02932f
C185 vtail.n153 VSS 0.01649f
C186 vtail.n154 VSS 0.02932f
C187 vtail.n155 VSS 0.01649f
C188 vtail.n156 VSS 0.02932f
C189 vtail.n157 VSS 0.01649f
C190 vtail.n158 VSS 0.02932f
C191 vtail.n159 VSS 0.01649f
C192 vtail.n160 VSS 0.02932f
C193 vtail.n161 VSS 0.01649f
C194 vtail.n162 VSS 0.02932f
C195 vtail.n163 VSS 0.01649f
C196 vtail.n164 VSS 0.02932f
C197 vtail.n165 VSS 0.01649f
C198 vtail.n166 VSS 0.02932f
C199 vtail.n167 VSS 0.01558f
C200 vtail.n168 VSS 0.02932f
C201 vtail.n169 VSS 0.01558f
C202 vtail.n170 VSS 0.02932f
C203 vtail.n172 VSS 0.02932f
C204 vtail.n173 VSS 0.01649f
C205 vtail.n174 VSS 0.02932f
C206 vtail.n175 VSS 0.01649f
C207 vtail.n176 VSS 0.02932f
C208 vtail.n177 VSS 0.01649f
C209 vtail.n178 VSS 0.02932f
C210 vtail.n179 VSS 0.01649f
C211 vtail.n180 VSS 0.02932f
C212 vtail.n181 VSS 0.01649f
C213 vtail.n182 VSS 0.02932f
C214 vtail.n183 VSS 0.01649f
C215 vtail.n184 VSS 0.08836f
C216 vtail.n185 VSS 0.01753f
C217 vtail.n186 VSS 0.02848f
C218 vtail.n187 VSS 0.01753f
C219 vtail.n188 VSS 0.01466f
C220 vtail.n189 VSS 0.01753f
C221 vtail.n190 VSS 0.01466f
C222 vtail.n191 VSS 0.01753f
C223 vtail.n192 VSS 0.01466f
C224 vtail.n193 VSS 0.01753f
C225 vtail.n194 VSS 0.01466f
C226 vtail.n195 VSS 0.01753f
C227 vtail.n196 VSS 0.01466f
C228 vtail.n197 VSS 0.01753f
C229 vtail.n198 VSS 0.01466f
C230 vtail.n199 VSS 0.01753f
C231 vtail.n200 VSS 0.01352f
C232 vtail.n201 VSS 0.01753f
C233 vtail.n202 VSS 0.01466f
C234 vtail.n203 VSS 0.01753f
C235 vtail.n204 VSS 0.01466f
C236 vtail.n205 VSS 0.01753f
C237 vtail.n206 VSS 0.01466f
C238 vtail.n207 VSS 0.01753f
C239 vtail.n208 VSS 0.01466f
C240 vtail.n209 VSS 0.01753f
C241 vtail.n210 VSS 0.01466f
C242 vtail.n211 VSS 0.01753f
C243 vtail.n212 VSS 0.01466f
C244 vtail.n213 VSS 0.01753f
C245 vtail.n214 VSS 0.01466f
C246 vtail.n215 VSS 0.01753f
C247 vtail.n216 VSS 0.01466f
C248 vtail.n226 VSS 0.46535f
C249 vtail.t6 VSS 0.23268f
C250 vtail.t2 VSS 0.23268f
C251 vtail.n227 VSS 0.11331f
C252 vtail.n228 VSS 0.39165f
C253 vtail.n229 VSS 0.04698f
C254 vtail.n230 VSS 0.05029f
C255 vtail.n231 VSS 0.04465f
C256 vtail.n232 VSS 0.01649f
C257 vtail.n233 VSS 0.09132f
C258 vtail.n234 VSS 0.01649f
C259 vtail.n235 VSS 0.02932f
C260 vtail.n236 VSS 0.01649f
C261 vtail.n237 VSS 0.02932f
C262 vtail.n238 VSS 0.01649f
C263 vtail.n239 VSS 0.02932f
C264 vtail.n240 VSS 0.01649f
C265 vtail.n241 VSS 0.02932f
C266 vtail.n242 VSS 0.01649f
C267 vtail.n243 VSS 0.02932f
C268 vtail.n244 VSS 0.01649f
C269 vtail.n245 VSS 0.02932f
C270 vtail.n246 VSS 0.02932f
C271 vtail.n247 VSS 0.02932f
C272 vtail.n248 VSS 0.01649f
C273 vtail.n249 VSS 0.02932f
C274 vtail.n250 VSS 0.0126f
C275 vtail.n251 VSS 0.02932f
C276 vtail.n252 VSS 0.01649f
C277 vtail.n253 VSS 0.02932f
C278 vtail.n254 VSS 0.01649f
C279 vtail.n255 VSS 0.02932f
C280 vtail.n256 VSS 0.01649f
C281 vtail.n257 VSS 0.02932f
C282 vtail.n258 VSS 0.01649f
C283 vtail.n259 VSS 0.02932f
C284 vtail.n260 VSS 0.01649f
C285 vtail.n261 VSS 0.02932f
C286 vtail.n262 VSS 0.01753f
C287 vtail.n263 VSS 0.01466f
C288 vtail.n264 VSS 0.01753f
C289 vtail.n265 VSS 0.01466f
C290 vtail.n266 VSS 0.01753f
C291 vtail.n267 VSS 0.01466f
C292 vtail.n268 VSS 0.01753f
C293 vtail.n269 VSS 0.01466f
C294 vtail.n270 VSS 0.01753f
C295 vtail.n271 VSS 0.01466f
C296 vtail.n272 VSS 0.01753f
C297 vtail.n273 VSS 0.01466f
C298 vtail.n274 VSS 0.01753f
C299 vtail.n276 VSS 0.01753f
C300 vtail.n277 VSS 0.01753f
C301 vtail.n278 VSS 0.01466f
C302 vtail.n279 VSS 0.01753f
C303 vtail.n280 VSS 0.01466f
C304 vtail.n281 VSS 0.01753f
C305 vtail.n282 VSS 0.01466f
C306 vtail.n283 VSS 0.01753f
C307 vtail.n284 VSS 0.01466f
C308 vtail.n285 VSS 0.01753f
C309 vtail.n286 VSS 0.01466f
C310 vtail.n287 VSS 0.01753f
C311 vtail.n288 VSS 0.01466f
C312 vtail.n289 VSS 0.01753f
C313 vtail.n290 VSS 0.02781f
C314 vtail.n291 VSS 0.01705f
C315 vtail.n300 VSS 0.44745f
C316 vtail.t10 VSS 0.22373f
C317 vtail.t11 VSS 0.22373f
C318 vtail.n301 VSS 0.01649f
C319 vtail.n302 VSS 0.02932f
C320 vtail.n303 VSS 0.0496f
C321 vtail.n304 VSS 0.04376f
C322 vtail.n305 VSS 0.08586f
C323 vtail.n306 VSS 0.01558f
C324 vtail.n307 VSS 0.02932f
C325 vtail.n308 VSS 0.01649f
C326 vtail.n309 VSS 0.02932f
C327 vtail.n310 VSS 0.01649f
C328 vtail.n311 VSS 0.02932f
C329 vtail.n312 VSS 0.01649f
C330 vtail.n313 VSS 0.02932f
C331 vtail.n314 VSS 0.01649f
C332 vtail.n315 VSS 0.02932f
C333 vtail.n316 VSS 0.01649f
C334 vtail.n317 VSS 0.02932f
C335 vtail.n318 VSS 0.01649f
C336 vtail.n319 VSS 0.02932f
C337 vtail.n320 VSS 0.01649f
C338 vtail.n321 VSS 0.02932f
C339 vtail.n322 VSS 0.01558f
C340 vtail.n323 VSS 0.02932f
C341 vtail.n324 VSS 0.01558f
C342 vtail.n325 VSS 0.02932f
C343 vtail.n326 VSS 0.01237f
C344 vtail.n327 VSS 0.02932f
C345 vtail.n328 VSS 0.01649f
C346 vtail.n329 VSS 0.02932f
C347 vtail.n330 VSS 0.01649f
C348 vtail.n331 VSS 0.02932f
C349 vtail.n332 VSS 0.01649f
C350 vtail.n333 VSS 0.02932f
C351 vtail.n334 VSS 0.01649f
C352 vtail.n335 VSS 0.02932f
C353 vtail.n336 VSS 0.01649f
C354 vtail.n337 VSS 0.02932f
C355 vtail.n338 VSS 0.01649f
C356 vtail.n339 VSS 0.08836f
C357 vtail.n340 VSS 0.01753f
C358 vtail.n341 VSS 0.02848f
C359 vtail.n342 VSS 0.01753f
C360 vtail.n343 VSS 0.01466f
C361 vtail.n344 VSS 0.01753f
C362 vtail.n345 VSS 0.01466f
C363 vtail.n346 VSS 0.01753f
C364 vtail.n347 VSS 0.01466f
C365 vtail.n348 VSS 0.01753f
C366 vtail.n349 VSS 0.01466f
C367 vtail.n350 VSS 0.01753f
C368 vtail.n351 VSS 0.01466f
C369 vtail.n352 VSS 0.01753f
C370 vtail.n353 VSS 0.01466f
C371 vtail.n354 VSS 0.01753f
C372 vtail.n356 VSS 0.01753f
C373 vtail.n357 VSS 0.01466f
C374 vtail.n358 VSS 0.01753f
C375 vtail.n359 VSS 0.01466f
C376 vtail.n360 VSS 0.01753f
C377 vtail.n361 VSS 0.01466f
C378 vtail.n362 VSS 0.01753f
C379 vtail.n363 VSS 0.01466f
C380 vtail.n364 VSS 0.01753f
C381 vtail.n365 VSS 0.01466f
C382 vtail.n366 VSS 0.01753f
C383 vtail.n367 VSS 0.01466f
C384 vtail.n368 VSS 0.01753f
C385 vtail.n369 VSS 0.01466f
C386 vtail.n370 VSS 0.01753f
C387 vtail.n371 VSS 0.01466f
C388 vtail.n381 VSS 0.46535f
C389 vtail.t1 VSS 0.23268f
C390 vtail.t5 VSS 0.23268f
C391 vtail.n382 VSS 0.11331f
C392 vtail.n383 VSS 0.39167f
C393 vtail.n384 VSS 0.05464f
C394 vtail.n385 VSS 0.04698f
C395 vtail.n386 VSS 0.05029f
C396 vtail.n387 VSS 0.01649f
C397 vtail.n388 VSS 0.02932f
C398 vtail.n389 VSS 0.01649f
C399 vtail.n390 VSS 0.02932f
C400 vtail.n391 VSS 0.01649f
C401 vtail.n392 VSS 0.02932f
C402 vtail.n393 VSS 0.01649f
C403 vtail.n394 VSS 0.02932f
C404 vtail.n395 VSS 0.01649f
C405 vtail.n396 VSS 0.02932f
C406 vtail.n397 VSS 0.01649f
C407 vtail.n398 VSS 0.02932f
C408 vtail.n400 VSS 0.02932f
C409 vtail.n401 VSS 0.01649f
C410 vtail.n402 VSS 0.02932f
C411 vtail.n403 VSS 0.02932f
C412 vtail.n404 VSS 0.02932f
C413 vtail.n405 VSS 0.01649f
C414 vtail.n406 VSS 0.02932f
C415 vtail.n407 VSS 0.01649f
C416 vtail.n408 VSS 0.02932f
C417 vtail.n409 VSS 0.01649f
C418 vtail.n410 VSS 0.02932f
C419 vtail.n411 VSS 0.01649f
C420 vtail.n412 VSS 0.02932f
C421 vtail.n413 VSS 0.01649f
C422 vtail.n414 VSS 0.02932f
C423 vtail.n415 VSS 0.01649f
C424 vtail.n416 VSS 0.02932f
C425 vtail.n417 VSS 0.01649f
C426 vtail.n418 VSS 0.09132f
C427 vtail.n419 VSS 0.01753f
C428 vtail.n420 VSS 0.02781f
C429 vtail.n421 VSS 0.01753f
C430 vtail.n422 VSS 0.01466f
C431 vtail.n423 VSS 0.01753f
C432 vtail.n424 VSS 0.01466f
C433 vtail.n425 VSS 0.01753f
C434 vtail.n426 VSS 0.01466f
C435 vtail.n427 VSS 0.01753f
C436 vtail.n428 VSS 0.01466f
C437 vtail.n429 VSS 0.01753f
C438 vtail.n430 VSS 0.01466f
C439 vtail.n431 VSS 0.01753f
C440 vtail.n432 VSS 0.01466f
C441 vtail.n433 VSS 0.01753f
C442 vtail.n434 VSS 0.01753f
C443 vtail.n435 VSS 0.01443f
C444 vtail.n436 VSS 0.01753f
C445 vtail.n437 VSS 0.01466f
C446 vtail.n438 VSS 0.01753f
C447 vtail.n439 VSS 0.01466f
C448 vtail.n440 VSS 0.01753f
C449 vtail.n441 VSS 0.01466f
C450 vtail.n442 VSS 0.01753f
C451 vtail.n443 VSS 0.01466f
C452 vtail.n444 VSS 0.01753f
C453 vtail.n445 VSS 0.01466f
C454 vtail.n446 VSS 0.01753f
C455 vtail.n447 VSS 0.01466f
C456 vtail.n456 VSS 0.44745f
C457 vtail.t8 VSS 0.22373f
C458 vtail.t9 VSS 0.22373f
C459 vtail.n457 VSS 0.0496f
C460 vtail.n458 VSS 0.04376f
C461 vtail.n459 VSS 0.08586f
C462 vtail.n460 VSS 0.01558f
C463 vtail.n461 VSS 0.02932f
C464 vtail.n462 VSS 0.01649f
C465 vtail.n463 VSS 0.02932f
C466 vtail.n464 VSS 0.01649f
C467 vtail.n465 VSS 0.02932f
C468 vtail.n466 VSS 0.01649f
C469 vtail.n467 VSS 0.02932f
C470 vtail.n468 VSS 0.01649f
C471 vtail.n469 VSS 0.02932f
C472 vtail.n470 VSS 0.01649f
C473 vtail.n471 VSS 0.02932f
C474 vtail.n472 VSS 0.01649f
C475 vtail.n473 VSS 0.02932f
C476 vtail.n474 VSS 0.01649f
C477 vtail.n475 VSS 0.02932f
C478 vtail.n476 VSS 0.01558f
C479 vtail.n477 VSS 0.02932f
C480 vtail.n478 VSS 0.01558f
C481 vtail.n479 VSS 0.02932f
C482 vtail.n480 VSS 0.01649f
C483 vtail.n481 VSS 0.02932f
C484 vtail.n482 VSS 0.01649f
C485 vtail.n483 VSS 0.02932f
C486 vtail.n484 VSS 0.0126f
C487 vtail.n485 VSS 0.02932f
C488 vtail.n486 VSS 0.01649f
C489 vtail.n487 VSS 0.02932f
C490 vtail.n488 VSS 0.01649f
C491 vtail.n489 VSS 0.02932f
C492 vtail.n490 VSS 0.01649f
C493 vtail.n491 VSS 0.02932f
C494 vtail.n492 VSS 0.01649f
C495 vtail.n493 VSS 0.08836f
C496 vtail.n494 VSS 0.01753f
C497 vtail.n495 VSS 0.02848f
C498 vtail.n496 VSS 0.01753f
C499 vtail.n497 VSS 0.01466f
C500 vtail.n498 VSS 0.01753f
C501 vtail.n499 VSS 0.01466f
C502 vtail.n500 VSS 0.01753f
C503 vtail.n501 VSS 0.01466f
C504 vtail.n502 VSS 0.01753f
C505 vtail.n503 VSS 0.01466f
C506 vtail.n504 VSS 0.01753f
C507 vtail.n506 VSS 0.01753f
C508 vtail.n507 VSS 0.01466f
C509 vtail.n508 VSS 0.01753f
C510 vtail.n509 VSS 0.01466f
C511 vtail.n510 VSS 0.01753f
C512 vtail.n511 VSS 0.01466f
C513 vtail.n512 VSS 0.01753f
C514 vtail.n513 VSS 0.01466f
C515 vtail.n514 VSS 0.01753f
C516 vtail.n515 VSS 0.01466f
C517 vtail.n516 VSS 0.01753f
C518 vtail.n517 VSS 0.01466f
C519 vtail.n518 VSS 0.01753f
C520 vtail.n519 VSS 0.01466f
C521 vtail.n520 VSS 0.01753f
C522 vtail.n521 VSS 0.01466f
C523 vtail.n522 VSS 0.01753f
C524 vtail.n523 VSS 0.01466f
C525 vtail.n524 VSS 0.01753f
C526 vtail.n525 VSS 0.01466f
C527 vtail.n535 VSS 0.46535f
C528 vtail.t4 VSS 0.23268f
C529 vtail.t0 VSS 0.23268f
C530 vtail.n536 VSS 0.13116f
C531 vtail.n537 VSS 0.0496f
C532 vtail.n538 VSS 0.04376f
C533 vtail.n539 VSS 0.08543f
C534 vtail.n540 VSS 0.01558f
C535 vtail.n541 VSS 0.02932f
C536 vtail.n542 VSS 0.01649f
C537 vtail.n543 VSS 0.02932f
C538 vtail.n544 VSS 0.01649f
C539 vtail.n545 VSS 0.02932f
C540 vtail.n546 VSS 0.01649f
C541 vtail.n547 VSS 0.02932f
C542 vtail.n548 VSS 0.01649f
C543 vtail.n549 VSS 0.02932f
C544 vtail.n550 VSS 0.01649f
C545 vtail.n551 VSS 0.02932f
C546 vtail.n552 VSS 0.01649f
C547 vtail.n553 VSS 0.02932f
C548 vtail.n554 VSS 0.01649f
C549 vtail.n555 VSS 0.02932f
C550 vtail.n556 VSS 0.01191f
C551 vtail.n557 VSS 0.02932f
C552 vtail.n559 VSS 0.02932f
C553 vtail.n560 VSS 0.01649f
C554 vtail.n561 VSS 0.02932f
C555 vtail.n562 VSS 0.01649f
C556 vtail.n563 VSS 0.02932f
C557 vtail.n564 VSS 0.01649f
C558 vtail.n565 VSS 0.02932f
C559 vtail.n566 VSS 0.01649f
C560 vtail.n567 VSS 0.02932f
C561 vtail.n568 VSS 0.01649f
C562 vtail.n569 VSS 0.02932f
C563 vtail.n570 VSS 0.01649f
C564 vtail.n571 VSS 0.02932f
C565 vtail.n572 VSS 0.01649f
C566 vtail.n573 VSS 0.08836f
C567 vtail.n574 VSS 0.01753f
C568 vtail.n575 VSS 0.02848f
C569 vtail.n576 VSS 0.01753f
C570 vtail.n577 VSS 0.01466f
C571 vtail.n578 VSS 0.01753f
C572 vtail.n579 VSS 0.01466f
C573 vtail.n580 VSS 0.01753f
C574 vtail.n581 VSS 0.01466f
C575 vtail.n582 VSS 0.01753f
C576 vtail.n583 VSS 0.01466f
C577 vtail.n584 VSS 0.01753f
C578 vtail.n585 VSS 0.01466f
C579 vtail.n586 VSS 0.01753f
C580 vtail.n587 VSS 0.01466f
C581 vtail.n588 VSS 0.01753f
C582 vtail.n589 VSS 0.01466f
C583 vtail.n590 VSS 0.01753f
C584 vtail.n591 VSS 0.01466f
C585 vtail.n592 VSS 0.01753f
C586 vtail.n593 VSS 0.01466f
C587 vtail.n594 VSS 0.01753f
C588 vtail.n595 VSS 0.01466f
C589 vtail.n596 VSS 0.01753f
C590 vtail.n597 VSS 0.01466f
C591 vtail.n598 VSS 0.01753f
C592 vtail.n599 VSS 0.01466f
C593 vtail.n600 VSS 0.01753f
C594 vtail.n601 VSS 0.01466f
C595 vtail.n602 VSS 0.01753f
C596 vtail.n603 VSS 0.01466f
C597 vtail.n604 VSS 0.01753f
C598 vtail.n605 VSS 0.01466f
C599 vtail.n615 VSS 0.46535f
C600 vtail.t3 VSS 0.23268f
C601 vtail.t7 VSS 0.23268f
C602 vtail.n616 VSS 0.02932f
C603 vtail.t15 VSS 0.22373f
C604 vd.t11 VSS 0.04159f
C605 vd.n0 VSS 0.01732f
C606 vd.n1 VSS 0.01092f
C607 vd.n2 VSS 0.01732f
C608 vd.n3 VSS 0.01092f
C609 vd.n7 VSS 0.01828f
C610 vd.n8 VSS 0.0365f
C611 vd.n9 VSS 0.03338f
C612 vd.n10 VSS 0.0365f
C613 vd.n11 VSS 0.10361f
C614 vd.n13 VSS 0.0198f
C615 vd.n14 VSS 0.03611f
C616 vd.n15 VSS 0.02808f
C617 vd.n16 VSS 0.04004f
C618 vd.n17 VSS 0.0106f
C619 vd.n18 VSS 0.01585f
C620 vd.n19 VSS 0.01092f
C621 vd.t4 VSS 0.16509f
C622 vd.n21 VSS 0.15079f
C623 vd.n22 VSS 0.01942f
C624 vd.n23 VSS 0.02001f
C625 vd.n24 VSS 0.0355f
C626 vd.n25 VSS 0.02855f
C627 vd.n26 VSS 0.03611f
C628 vd.n27 VSS 0.01584f
C629 vd.n28 VSS 0.01092f
C630 vd.t15 VSS 0.16509f
C631 vd.n31 VSS 0.15079f
C632 vd.n32 VSS 0.01942f
C633 vd.n33 VSS 0.0173f
C634 vd.n34 VSS 0.0358f
C635 vd.n35 VSS 0.02926f
C636 vd.n36 VSS 0.0355f
C637 vd.n37 VSS 0.01193f
C638 vd.n38 VSS 0.01585f
C639 vd.n39 VSS 0.01092f
C640 vd.t14 VSS 0.16509f
C641 vd.n41 VSS 0.15079f
C642 vd.n42 VSS 0.01942f
C643 vd.n43 VSS 0.0198f
C644 vd.n44 VSS 0.02276f
C645 vd.n45 VSS 0.02675f
C646 vd.n46 VSS 0.0358f
C647 vd.n47 VSS 0.01193f
C648 vd.n48 VSS 0.01585f
C649 vd.n49 VSS 0.01092f
C650 vd.t6 VSS 0.16509f
C651 vd.n51 VSS 0.15079f
C652 vd.n52 VSS 0.01942f
C653 vd.n53 VSS 0.0198f
C654 vd.n54 VSS 0.0358f
C655 vd.n55 VSS 0.02675f
C656 vd.n56 VSS 0.02276f
C657 vd.n57 VSS 0.0106f
C658 vd.n58 VSS 0.01585f
C659 vd.n59 VSS 0.01092f
C660 vd.t8 VSS 0.16509f
C661 vd.n61 VSS 0.15079f
C662 vd.n62 VSS 0.01942f
C663 vd.n63 VSS 0.01922f
C664 vd.n64 VSS 0.03611f
C665 vd.n65 VSS 0.02926f
C666 vd.n66 VSS 0.0358f
C667 vd.n67 VSS 0.01001f
C668 vd.n68 VSS 0.01585f
C669 vd.n69 VSS 0.01092f
C670 vd.t13 VSS 0.16509f
C671 vd.n71 VSS 0.15079f
C672 vd.n72 VSS 0.01942f
C673 vd.n73 VSS 0.0178f
C674 vd.n74 VSS 0.0355f
C675 vd.n75 VSS 0.02855f
C676 vd.n76 VSS 0.03611f
C677 vd.n77 VSS 0.01584f
C678 vd.n78 VSS 0.01092f
C679 vd.t12 VSS 0.16509f
C680 vd.n81 VSS 0.15079f
C681 vd.n83 VSS 0.01942f
C682 vd.n84 VSS 0.0198f
C683 vd.n85 VSS 0.03966f
C684 vd.n86 VSS 0.02896f
C685 vd.n87 VSS 0.0355f
C686 vd.n89 VSS 0.01585f
C687 vd.n90 VSS 0.01092f
C688 vd.t10 VSS 0.16509f
C689 vd.n92 VSS 0.15079f
C690 vd.n93 VSS 0.01942f
C691 vd.n94 VSS 0.03875f
C692 vd.n96 VSS 0.01942f
C693 vd.n97 VSS 0.0365f
C694 vd.n98 VSS 0.03824f
C695 vd.n99 VSS 0.0365f
C696 vd.n100 VSS 0.10525f
C697 vd.n101 VSS 0.01092f
C698 vd.n103 VSS 0.01092f
C699 vd.n105 VSS 0.01732f
C700 vd.n106 VSS 0.01732f
C701 vd.t5 VSS 0.04159f
C702 vd.n108 VSS 0.01942f
C703 vd.n109 VSS 0.03124f
C704 vd.n110 VSS 0.10296f
C705 vd.n112 VSS 0.01828f
C706 vd.n113 VSS 0.01028f
C707 vd.n114 VSS 0.0182f
C708 vd.n115 VSS 0.01028f
C709 vd.n116 VSS 0.01128f
C710 vd.n117 VSS 0.0468f
C711 vd.n118 VSS 0.01028f
C712 vd.n119 VSS 0.01128f
C713 vd.n120 VSS 0.02728f
C714 vd.n121 VSS 0.10325f
C715 vd.n122 VSS 0.01028f
C716 vd.n123 VSS 0.0182f
C717 vd.n124 VSS 0.03091f
C718 vd.n125 VSS 0.01028f
C719 vd.n126 VSS 0.05507f
C720 vd.n127 VSS 0.01028f
C721 vd.n128 VSS 0.01828f
C722 vd.n129 VSS 0.01028f
C723 vd.n130 VSS 0.01828f
C724 vd.n131 VSS 0.01028f
C725 vd.n132 VSS 0.01828f
C726 vd.n133 VSS 0.01028f
C727 vd.n134 VSS 0.01828f
C728 vd.n135 VSS 0.01028f
C729 vd.n136 VSS 0.01828f
C730 vd.n137 VSS 0.01028f
C731 vd.n138 VSS 0.01828f
C732 vd.n140 VSS 0.01828f
C733 vd.n142 VSS 0.01828f
C734 vd.n143 VSS 0.01028f
C735 vd.n144 VSS 0.01828f
C736 vd.n145 VSS 0.01028f
C737 vd.n146 VSS 0.01828f
C738 vd.n147 VSS 0.01028f
C739 vd.n148 VSS 0.01828f
C740 vd.n149 VSS 0.01028f
C741 vd.n150 VSS 0.01828f
C742 vd.n151 VSS 0.01028f
C743 vd.n152 VSS 0.01764f
C744 vd.n153 VSS 0.01092f
C745 vd.n155 VSS 0.01092f
C746 vd.n157 VSS 0.01092f
C747 vd.n159 VSS 0.01092f
C748 vd.n161 VSS 0.01092f
C749 vd.n163 VSS 0.01092f
C750 vd.n165 VSS 0.01092f
C751 vd.n167 VSS 0.01092f
C752 vd.n169 VSS 0.01092f
C753 vd.n171 VSS 0.01092f
C754 vd.n173 VSS 0.01092f
C755 vd.n175 VSS 0.01092f
C756 vd.n177 VSS 0.01092f
C757 vd.n179 VSS 0.01092f
C758 vd.n181 VSS 0.01092f
C759 vd.n183 VSS 0.01092f
C760 vd.n184 VSS 0.01775f
C761 vd.n194 VSS 0.29002f
C762 vd.t1 VSS 0.14501f
C763 vd.t3 VSS 0.14501f
C764 vd.n196 VSS 0.01828f
C765 vd.n198 VSS 0.01828f
C766 vd.n199 VSS 0.02999f
C767 vd.n200 VSS 0.02261f
C768 vd.n201 VSS 0.02999f
C769 vd.n202 VSS 0.10361f
C770 vd.n203 VSS 0.01092f
C771 vd.n205 VSS 0.01092f
C772 vd.n209 VSS 0.06693f
C773 vd.t7 VSS 0.03346f
C774 vd.t9 VSS 0.03346f
C775 vd.n211 VSS 0.01828f
C776 vd.n212 VSS 0.01064f
C777 vd.n213 VSS 0.58631f
C778 vd.n214 VSS 0.01028f
C779 vd.n215 VSS 0.01101f
C780 vd.n216 VSS 0.03124f
C781 vd.n217 VSS 0.10325f
C782 vd.n218 VSS 0.01028f
C783 vd.n219 VSS 0.01824f
C784 vd.n220 VSS 0.03487f
C785 vd.n221 VSS 0.01028f
C786 vd.n222 VSS 0.05507f
C787 vd.n223 VSS 0.01028f
C788 vd.n224 VSS 0.01828f
C789 vd.n225 VSS 0.01028f
C790 vd.n226 VSS 0.01828f
C791 vd.n227 VSS 0.01028f
C792 vd.n228 VSS 0.01828f
C793 vd.n229 VSS 0.01028f
C794 vd.n230 VSS 0.01828f
C795 vd.n231 VSS 0.01028f
C796 vd.n232 VSS 0.01828f
C797 vd.n233 VSS 0.01028f
C798 vd.n234 VSS 0.01828f
C799 vd.n236 VSS 0.01828f
C800 vd.n238 VSS 0.01828f
C801 vd.n240 VSS 0.01828f
C802 vd.n241 VSS 0.01028f
C803 vd.n242 VSS 0.01828f
C804 vd.n243 VSS 0.01028f
C805 vd.n244 VSS 0.01828f
C806 vd.n245 VSS 0.01028f
C807 vd.n246 VSS 0.01828f
C808 vd.n247 VSS 0.01028f
C809 vd.n248 VSS 0.0179f
C810 vd.n249 VSS 0.01092f
C811 vd.n251 VSS 0.01092f
C812 vd.n253 VSS 0.01092f
C813 vd.n255 VSS 0.01092f
C814 vd.n257 VSS 0.01092f
C815 vd.n259 VSS 0.01092f
C816 vd.n261 VSS 0.01092f
C817 vd.n263 VSS 0.01092f
C818 vd.n265 VSS 0.01092f
C819 vd.n267 VSS 0.01092f
C820 vd.n269 VSS 0.01092f
C821 vd.n271 VSS 0.01092f
C822 vd.n273 VSS 0.01092f
C823 vd.n275 VSS 0.01092f
C824 vd.n277 VSS 0.01092f
C825 vd.n279 VSS 0.01092f
C826 vd.n280 VSS 0.01775f
C827 vd.n281 VSS 0.01987f
C828 vd.n282 VSS 0.03885f
C829 vd.n283 VSS 0.01928f
C830 vd.n284 VSS 0.01928f
C831 vd.n285 VSS 0.01928f
C832 vd.n286 VSS 0.01928f
C833 vd.n287 VSS 0.01928f
C834 vd.n288 VSS 0.01446f
C835 vd.n289 VSS 0.01446f
C836 vd.n290 VSS 0.01928f
C837 vd.n291 VSS 0.01928f
C838 vd.n292 VSS 0.01928f
C839 vd.n293 VSS 0.01928f
C840 vd.n294 VSS 0.01928f
C841 vd.n295 VSS 0.03885f
C842 vd.n296 VSS 0.01995f
C843 vd.n298 VSS 0.01828f
C844 vd.n299 VSS 0.04678f
C845 vd.n300 VSS 0.03487f
C846 vd.n301 VSS 0.01028f
C847 vd.n302 VSS 0.01764f
C848 vd.n303 VSS 0.01028f
C849 vd.n304 VSS 0.01828f
C850 vd.n305 VSS 0.01028f
C851 vd.n306 VSS 0.01828f
C852 vd.n307 VSS 0.01028f
C853 vd.n308 VSS 0.01828f
C854 vd.n310 VSS 0.01828f
C855 vd.n312 VSS 0.01828f
C856 vd.n314 VSS 0.01828f
C857 vd.n315 VSS 0.01028f
C858 vd.n316 VSS 0.01828f
C859 vd.n317 VSS 0.01028f
C860 vd.n318 VSS 0.01828f
C861 vd.n319 VSS 0.01028f
C862 vd.n320 VSS 0.01828f
C863 vd.n321 VSS 0.01028f
C864 vd.n322 VSS 0.01828f
C865 vd.n323 VSS 0.01028f
C866 vd.n324 VSS 0.01828f
C867 vd.n325 VSS 0.01028f
C868 vd.n326 VSS 0.01828f
C869 vd.n327 VSS 0.01028f
C870 vd.n328 VSS 0.05507f
C871 vd.n329 VSS 0.01092f
C872 vd.n330 VSS 0.01775f
C873 vd.n331 VSS 0.01092f
C874 vd.n333 VSS 0.01092f
C875 vd.n335 VSS 0.01092f
C876 vd.n337 VSS 0.01092f
C877 vd.n339 VSS 0.01092f
C878 vd.n341 VSS 0.01092f
C879 vd.n343 VSS 0.01092f
C880 vd.n345 VSS 0.01092f
C881 vd.n347 VSS 0.01092f
C882 vd.n349 VSS 0.01092f
C883 vd.n351 VSS 0.01092f
C884 vd.n353 VSS 0.01092f
C885 vd.n355 VSS 0.01092f
C886 vd.n357 VSS 0.01092f
C887 vd.n359 VSS 0.01092f
C888 vd.n361 VSS 0.01995f
C889 vd.n362 VSS 0.01987f
C890 vd.n363 VSS 0.03885f
C891 vd.n364 VSS 0.01928f
C892 vd.n365 VSS 0.01928f
C893 vd.n366 VSS 0.01928f
C894 vd.n367 VSS 0.01928f
C895 vd.n368 VSS 0.01928f
C896 vd.n369 VSS 0.01446f
C897 vd.n370 VSS 0.01446f
C898 vd.n371 VSS 0.01928f
C899 vd.n372 VSS 0.01928f
C900 vd.n373 VSS 0.01928f
C901 vd.n374 VSS 0.01928f
C902 vd.n375 VSS 0.01928f
C903 vd.n376 VSS 0.03885f
C904 vd.n377 VSS 0.01828f
C905 vo1.n2 VSS 0.01263f
C906 vo1.t4 VSS 0.02313f
C907 vo1.n6 VSS 0.01263f
C908 vo1.t1 VSS 0.10022f
C909 vo1.n20 VSS 0.01227f
C910 vo1.n21 VSS 0.02136f
C911 vo1.n22 VSS 0.03806f
C912 vo1.n26 VSS 0.01051f
C913 vo1.n27 VSS 0.01263f
C914 vo1.n29 VSS 0.01255f
C915 vo1.n32 VSS 0.01263f
C916 vo1.n33 VSS 0.01263f
C917 vo1.n35 VSS 0.01263f
C918 vo1.n44 VSS 0.01263f
C919 vo1.n45 VSS 0.01263f
C920 vo1.n57 VSS 0.01727f
C921 vo1.n60 VSS 0.01554f
C922 vo1.n63 VSS 0.01303f
C923 vo1.n65 VSS 0.01492f
C924 vo1.n66 VSS 0.01274f
C925 vo1.n67 VSS 0.01642f
C926 vo1.n68 VSS 0.01144f
C927 vo1.n69 VSS 0.01209f
C928 vo1.n70 VSS 0.01144f
C929 vo1.n71 VSS 0.01554f
C930 vo1.n72 VSS 0.01554f
C931 vo1.n77 VSS 0.03232f
C932 vo1.n78 VSS 0.01729f
C933 vo1.n85 VSS 0.01187f
C934 vo1.n86 VSS 0.01761f
C935 vo1.n87 VSS 0.03071f
C936 vo1.n88 VSS 0.02104f
C937 vo1.n89 VSS 0.01465f
C938 vo1.n90 VSS 0.12228f
C939 vo1.n91 VSS 0.01184f
C940 vo1.n92 VSS 0.01255f
C941 vo1.t0 VSS 0.10022f
C942 vo1.n102 VSS 0.01263f
C943 vo1.n103 VSS 0.01263f
C944 vo1.n105 VSS 0.01885f
C945 vo1.n106 VSS 0.01263f
C946 vo1.n107 VSS 0.01263f
C947 vo1.t7 VSS 0.02313f
C948 vo1.t5 VSS 0.02313f
C949 vo1.n110 VSS 0.04625f
C950 vo1.n113 VSS 0.02914f
C951 vo1.n114 VSS 0.02119f
C952 vo1.n119 VSS 0.02073f
C953 vo1.n120 VSS 0.0716f
C954 vo1.n121 VSS 0.07135f
C955 vo1.n122 VSS 0.01263f
C956 vo1.n132 VSS 0.01263f
C957 vo1.n133 VSS 0.01263f
C958 vo1.n143 VSS 0.01227f
C959 vo1.n144 VSS 0.01263f
C960 vo1.n147 VSS 0.01255f
C961 vo1.n148 VSS 0.01263f
C962 vo1.n152 VSS 0.01263f
C963 vo1.n153 VSS 0.01263f
C964 vo1.n164 VSS 0.01051f
C965 vo1.n165 VSS 0.01628f
C966 vo1.t16 VSS 0.13568f
C967 vo1.n169 VSS 0.01945f
C968 vo1.n174 VSS 0.01628f
C969 vo1.t15 VSS 0.13568f
C970 vo1.n178 VSS 0.01945f
C971 vo1.n183 VSS 0.01628f
C972 vo1.t14 VSS 0.13568f
C973 vo1.n187 VSS 0.01945f
C974 vo1.n191 VSS 0.01628f
C975 vo1.t13 VSS 0.13568f
C976 vo1.n195 VSS 0.01945f
C977 vo1.n199 VSS 0.01628f
C978 vo1.t12 VSS 0.13568f
C979 vo1.n203 VSS 0.01945f
C980 vo1.n207 VSS 0.01628f
C981 vo1.t11 VSS 0.13568f
C982 vo1.n211 VSS 0.01945f
C983 vo1.n216 VSS 0.01628f
C984 vo1.t10 VSS 0.13568f
C985 vo1.n220 VSS 0.01945f
C986 vo1.n225 VSS 0.01628f
C987 vo1.t9 VSS 0.13568f
C988 vo1.n229 VSS 0.01945f
C989 vo1.n233 VSS 0.01499f
C990 vo1.n234 VSS 0.02371f
C991 vo1.n240 VSS 0.0323f
C992 vo1.n241 VSS 0.01628f
C993 vo1.n248 VSS 0.153f
C994 vo1.n249 VSS 0.01945f
C995 vo1.n250 VSS 0.02371f
C996 vo1.n251 VSS 0.01472f
C997 vo1.n252 VSS 0.02535f
C998 vo1.n253 VSS 0.02535f
C999 vo1.n254 VSS 0.01473f
C1000 vo1.n255 VSS 0.02391f
C1001 vo1.n260 VSS 0.01628f
C1002 vo1.n261 VSS 0.01628f
C1003 vo1.n268 VSS 0.153f
C1004 vo1.n269 VSS 0.01945f
C1005 vo1.n270 VSS 0.02352f
C1006 vo1.n271 VSS 0.01471f
C1007 vo1.n272 VSS 0.02572f
C1008 vo1.n273 VSS 0.02572f
C1009 vo1.n274 VSS 0.01472f
C1010 vo1.n275 VSS 0.02371f
C1011 vo1.n280 VSS 0.01628f
C1012 vo1.n281 VSS 0.01628f
C1013 vo1.n288 VSS 0.153f
C1014 vo1.n289 VSS 0.01945f
C1015 vo1.n290 VSS 0.02371f
C1016 vo1.n291 VSS 0.01472f
C1017 vo1.n292 VSS 0.02553f
C1018 vo1.n293 VSS 0.02553f
C1019 vo1.n294 VSS 0.01472f
C1020 vo1.n295 VSS 0.02371f
C1021 vo1.n301 VSS 0.01628f
C1022 vo1.n302 VSS 0.01628f
C1023 vo1.n309 VSS 0.153f
C1024 vo1.n310 VSS 0.01945f
C1025 vo1.n311 VSS 0.02371f
C1026 vo1.n312 VSS 0.01472f
C1027 vo1.n313 VSS 0.02553f
C1028 vo1.n314 VSS 0.02553f
C1029 vo1.n315 VSS 0.01472f
C1030 vo1.n316 VSS 0.02371f
C1031 vo1.n322 VSS 0.01628f
C1032 vo1.n323 VSS 0.01628f
C1033 vo1.n330 VSS 0.153f
C1034 vo1.n331 VSS 0.01945f
C1035 vo1.n332 VSS 0.02371f
C1036 vo1.n333 VSS 0.01472f
C1037 vo1.n334 VSS 0.02553f
C1038 vo1.n335 VSS 0.02553f
C1039 vo1.n336 VSS 0.01472f
C1040 vo1.n337 VSS 0.02371f
C1041 vo1.n343 VSS 0.01628f
C1042 vo1.n344 VSS 0.01628f
C1043 vo1.n351 VSS 0.153f
C1044 vo1.n352 VSS 0.01945f
C1045 vo1.n353 VSS 0.02371f
C1046 vo1.n354 VSS 0.01472f
C1047 vo1.n355 VSS 0.02572f
C1048 vo1.n356 VSS 0.02572f
C1049 vo1.n357 VSS 0.01471f
C1050 vo1.n358 VSS 0.02352f
C1051 vo1.n363 VSS 0.01628f
C1052 vo1.n364 VSS 0.01628f
C1053 vo1.n371 VSS 0.153f
C1054 vo1.n372 VSS 0.01945f
C1055 vo1.n373 VSS 0.02391f
C1056 vo1.n374 VSS 0.01473f
C1057 vo1.n375 VSS 0.02553f
C1058 vo1.n376 VSS 0.02553f
C1059 vo1.n377 VSS 0.01471f
C1060 vo1.n378 VSS 0.02352f
C1061 vo1.n383 VSS 0.01628f
C1062 vo1.n384 VSS 0.01628f
C1063 vo1.n391 VSS 0.153f
C1064 vo1.n392 VSS 0.01945f
C1065 vo1.n393 VSS 0.02391f
C1066 vo1.n394 VSS 0.01473f
C1067 vo1.n395 VSS 0.12037f
C1068 vo1.n396 VSS 0.03295f
C1069 vo1.n397 VSS 0.31711f
C1070 vo1.n409 VSS 0.03806f
C1071 vo1.n410 VSS 0.02136f
C1072 vo1.t2 VSS 0.10022f
C1073 vo1.n412 VSS 0.20043f
C1074 vo1.n419 VSS 0.31767f
C1075 vo1.n420 VSS 0.03295f
C1076 vo1.n421 VSS 0.01184f
C1077 vo1.n428 VSS 0.01263f
C1078 vo1.n429 VSS 0.01263f
C1079 vo1.n439 VSS 0.01255f
C1080 vo1.n440 VSS 0.01263f
C1081 vo1.t3 VSS 0.10022f
C1082 vo1.n445 VSS 0.20043f
C1083 vo1.n447 VSS 0.01885f
C1084 vo1.n448 VSS 0.07135f
C1085 vo1.n449 VSS 0.0716f
C1086 vo1.n450 VSS 0.02073f
C1087 vo1.t8 VSS 0.02313f
C1088 vo1.n452 VSS 0.04625f
C1089 vo1.n454 VSS 0.02119f
C1090 vo1.n455 VSS 0.02914f
C1091 a_8092_n697.n2 VSS 0.02192f
C1092 a_8092_n697.n6 VSS 0.02192f
C1093 a_8092_n697.n9 VSS 0.02854f
C1094 a_8092_n697.n14 VSS 0.02192f
C1095 a_8092_n697.n21 VSS 0.02192f
C1096 a_8092_n697.n27 VSS 0.02161f
C1097 a_4664_n951.n5 VSS 0.04214f
C1098 a_4664_n951.n7 VSS 0.01848f
C1099 a_4664_n951.n15 VSS 0.01061f
C1100 a_4664_n951.n16 VSS 0.01848f
C1101 a_4664_n951.n17 VSS 0.0486f
C1102 a_4664_n951.n18 VSS 0.04214f
C1103 a_4664_n951.n21 VSS 0.01061f
C1104 a_4664_n951.n25 VSS 0.04214f
C1105 a_4664_n951.n26 VSS 0.04214f
C1106 a_4664_n951.n27 VSS 0.03804f
C1107 a_8092_n1205.n2 VSS 0.03657f
C1108 a_8092_n1205.n6 VSS 0.03657f
C1109 a_8092_n1205.n8 VSS 0.01573f
C1110 a_8092_n1205.n9 VSS 0.04761f
C1111 a_8092_n1205.n10 VSS 0.01573f
C1112 a_8092_n1205.n14 VSS 0.03657f
C1113 a_8092_n1205.n21 VSS 0.03657f
C1114 a_8092_n1205.n27 VSS 0.03505f
C1115 a_4664_n1459.n5 VSS 0.04184f
C1116 a_4664_n1459.n7 VSS 0.01841f
C1117 a_4664_n1459.n15 VSS 0.01057f
C1118 a_4664_n1459.n16 VSS 0.01841f
C1119 a_4664_n1459.n17 VSS 0.05178f
C1120 a_4664_n1459.n18 VSS 0.04184f
C1121 a_4664_n1459.n21 VSS 0.01057f
C1122 a_4664_n1459.n25 VSS 0.04184f
C1123 a_4664_n1459.n26 VSS 0.04184f
C1124 a_4664_n1459.n27 VSS 0.04184f
C1125 a_8092_n1713.n2 VSS 0.02022f
C1126 a_8092_n1713.n6 VSS 0.02022f
C1127 a_8092_n1713.n9 VSS 0.02632f
C1128 a_8092_n1713.n14 VSS 0.02022f
C1129 a_8092_n1713.n21 VSS 0.02022f
C1130 a_8092_n1713.n27 VSS 0.0205f
C1131 vmiler.t1 VSS 0.18023p
C1132 vmiler.n11 VSS 1.75453f
C1133 vmiler.n12 VSS 0.05066f
C1134 vgp.t3 VSS 0.1426f
C1135 vgp.n0 VSS 0.2852f
C1136 vgp.n1 VSS 0.01071f
C1137 vgp.n2 VSS 0.01117f
C1138 vgp.n4 VSS 0.01117f
C1139 vgp.n5 VSS 0.01117f
C1140 vgp.n7 VSS 0.01117f
C1141 vgp.n8 VSS 0.01117f
C1142 vgp.n10 VSS 0.01117f
C1143 vgp.n11 VSS 0.01117f
C1144 vgp.n13 VSS 0.01117f
C1145 vgp.n14 VSS 0.01117f
C1146 vgp.n16 VSS 0.01117f
C1147 vgp.n17 VSS 0.01117f
C1148 vgp.n19 VSS 0.01117f
C1149 vgp.n20 VSS 0.01117f
C1150 vgp.n22 VSS 0.01117f
C1151 vgp.n23 VSS 0.01117f
C1152 vgp.n25 VSS 0.02366f
C1153 vgp.n33 VSS 0.01869f
C1154 vgp.n40 VSS 0.01772f
C1155 vgp.n41 VSS 0.03059f
C1156 vgp.n42 VSS 0.07838f
C1157 vgp.n44 VSS 0.01051f
C1158 vgp.n45 VSS 0.0582f
C1159 vgp.n46 VSS 0.01051f
C1160 vgp.n47 VSS 0.01869f
C1161 vgp.n48 VSS 0.01051f
C1162 vgp.n49 VSS 0.01869f
C1163 vgp.n50 VSS 0.01051f
C1164 vgp.n51 VSS 0.01869f
C1165 vgp.n52 VSS 0.01051f
C1166 vgp.n53 VSS 0.01869f
C1167 vgp.n54 VSS 0.01051f
C1168 vgp.n55 VSS 0.01869f
C1169 vgp.n56 VSS 0.01051f
C1170 vgp.n57 VSS 0.01869f
C1171 vgp.n58 VSS 0.01869f
C1172 vgp.n59 VSS 0.01051f
C1173 vgp.n60 VSS 0.01869f
C1174 vgp.n61 VSS 0.01051f
C1175 vgp.n62 VSS 0.01869f
C1176 vgp.n63 VSS 0.01051f
C1177 vgp.n64 VSS 0.01869f
C1178 vgp.n65 VSS 0.01051f
C1179 vgp.n66 VSS 0.01869f
C1180 vgp.n67 VSS 0.01051f
C1181 vgp.n68 VSS 0.01869f
C1182 vgp.n69 VSS 0.01051f
C1183 vgp.n70 VSS 0.01869f
C1184 vgp.n71 VSS 0.01051f
C1185 vgp.n72 VSS 0.01869f
C1186 vgp.n73 VSS 0.01051f
C1187 vgp.n74 VSS 0.04035f
C1188 vgp.n75 VSS 0.07793f
C1189 vgp.n77 VSS 0.01869f
C1190 vgp.n78 VSS 0.01051f
C1191 vgp.n79 VSS 0.01869f
C1192 vgp.n80 VSS 0.01051f
C1193 vgp.n81 VSS 0.01869f
C1194 vgp.n82 VSS 0.01051f
C1195 vgp.n83 VSS 0.01869f
C1196 vgp.n84 VSS 0.01051f
C1197 vgp.n85 VSS 0.01869f
C1198 vgp.n86 VSS 0.01051f
C1199 vgp.n87 VSS 0.01869f
C1200 vgp.n89 VSS 0.01869f
C1201 vgp.n91 VSS 0.01869f
C1202 vgp.n92 VSS 0.01051f
C1203 vgp.n93 VSS 0.01869f
C1204 vgp.n94 VSS 0.01051f
C1205 vgp.n95 VSS 0.01869f
C1206 vgp.n96 VSS 0.01051f
C1207 vgp.n97 VSS 0.01869f
C1208 vgp.n98 VSS 0.01051f
C1209 vgp.n99 VSS 0.01869f
C1210 vgp.n100 VSS 0.01051f
C1211 vgp.n101 VSS 0.01869f
C1212 vgp.n102 VSS 0.01051f
C1213 vgp.n103 VSS 0.01869f
C1214 vgp.n104 VSS 0.01051f
C1215 vgp.n105 VSS 0.01869f
C1216 vgp.n107 VSS 0.01869f
C1217 vgp.n109 VSS 0.01869f
C1218 vgp.n110 VSS 0.01051f
C1219 vgp.n111 VSS 0.01869f
C1220 vgp.n112 VSS 0.01051f
C1221 vgp.n113 VSS 0.01869f
C1222 vgp.n114 VSS 0.01051f
C1223 vgp.n115 VSS 0.01869f
C1224 vgp.n116 VSS 0.01051f
C1225 vgp.n117 VSS 0.01869f
C1226 vgp.n118 VSS 0.01051f
C1227 vgp.n119 VSS 0.05369f
C1228 vgp.n120 VSS 0.01117f
C1229 vgp.n121 VSS 0.01524f
C1230 vgp.n122 VSS 0.01117f
C1231 vgp.n124 VSS 0.01117f
C1232 vgp.n126 VSS 0.01117f
C1233 vgp.n128 VSS 0.01117f
C1234 vgp.n130 VSS 0.01117f
C1235 vgp.n132 VSS 0.01117f
C1236 vgp.n134 VSS 0.01117f
C1237 vgp.n136 VSS 0.01117f
C1238 vgp.n138 VSS 0.01117f
C1239 vgp.n140 VSS 0.01117f
C1240 vgp.n142 VSS 0.01117f
C1241 vgp.n144 VSS 0.01117f
C1242 vgp.n146 VSS 0.01117f
C1243 vgp.n148 VSS 0.01117f
C1244 vgp.n150 VSS 0.01117f
C1245 vgp.n152 VSS 0.01117f
C1246 vgp.n154 VSS 0.01117f
C1247 vgp.n156 VSS 0.01117f
C1248 vgp.n158 VSS 0.01117f
C1249 vgp.n160 VSS 0.02537f
C1250 vgp.n161 VSS 0.03376f
C1251 vgp.n162 VSS 0.01971f
C1252 vgp.n163 VSS 0.01971f
C1253 vgp.n164 VSS 0.01971f
C1254 vgp.n165 VSS 0.01971f
C1255 vgp.n166 VSS 0.01971f
C1256 vgp.n167 VSS 0.01971f
C1257 vgp.n168 VSS 0.01971f
C1258 vgp.n169 VSS 0.01479f
C1259 vgp.n170 VSS 0.01479f
C1260 vgp.n171 VSS 0.01971f
C1261 vgp.n172 VSS 0.01971f
C1262 vgp.n173 VSS 0.01971f
C1263 vgp.n174 VSS 0.01971f
C1264 vgp.n175 VSS 0.01971f
C1265 vgp.n176 VSS 0.01971f
C1266 vgp.n177 VSS 0.01971f
C1267 vgp.n178 VSS 0.03376f
C1268 vgp.n179 VSS 0.0253f
C1269 vgp.n180 VSS 0.03336f
C1270 vgp.n181 VSS 0.01869f
C1271 vgp.n182 VSS 0.29673f
C1272 vgp.t0 VSS 0.92618f
C1273 vgp.n183 VSS 0.01619f
C1274 vgp.n184 VSS 0.06598f
C1275 vgp.n185 VSS 0.01117f
C1276 vgp.n186 VSS 0.01479f
C1277 vgp.t2 VSS 0.81911f
C1278 vgp.n188 VSS 0.37097f
C1279 vgp.n189 VSS 0.02527f
C1280 vgp.n190 VSS 0.01619f
C1281 vgp.n191 VSS 0.03121f
C1282 vgp.n192 VSS 0.01117f
C1283 vgp.t20 VSS 0.81911f
C1284 vgp.n194 VSS 0.37097f
C1285 vgp.n195 VSS 0.07565f
C1286 vgp.n196 VSS 0.01619f
C1287 vgp.n197 VSS 0.03121f
C1288 vgp.n198 VSS 0.01117f
C1289 vgp.n199 VSS 0.01451f
C1290 vgp.t19 VSS 0.81911f
C1291 vgp.n201 VSS 0.37097f
C1292 vgp.n202 VSS 0.03622f
C1293 vgp.n203 VSS 0.01619f
C1294 vgp.n204 VSS 0.03121f
C1295 vgp.n205 VSS 0.01117f
C1296 vgp.n206 VSS 0.01218f
C1297 vgp.t18 VSS 0.81911f
C1298 vgp.n208 VSS 0.37097f
C1299 vgp.n209 VSS 0.03855f
C1300 vgp.n210 VSS 0.01619f
C1301 vgp.n211 VSS 0.02889f
C1302 vgp.n212 VSS 0.01117f
C1303 vgp.n213 VSS 0.01218f
C1304 vgp.t17 VSS 0.81911f
C1305 vgp.n215 VSS 0.37097f
C1306 vgp.n216 VSS 0.04088f
C1307 vgp.n217 VSS 0.01619f
C1308 vgp.n218 VSS 0.02889f
C1309 vgp.n219 VSS 0.01117f
C1310 vgp.n220 VSS 0.01218f
C1311 vgp.t16 VSS 0.81911f
C1312 vgp.n222 VSS 0.37097f
C1313 vgp.n223 VSS 0.04088f
C1314 vgp.n224 VSS 0.01619f
C1315 vgp.n225 VSS 0.02368f
C1316 vgp.n226 VSS 0.01117f
C1317 vgp.n227 VSS 0.01739f
C1318 vgp.t15 VSS 0.81911f
C1319 vgp.n229 VSS 0.37097f
C1320 vgp.n230 VSS 0.04088f
C1321 vgp.n231 VSS 0.01619f
C1322 vgp.n232 VSS 0.02683f
C1323 vgp.n233 VSS 0.01117f
C1324 vgp.n234 VSS 0.01424f
C1325 vgp.t14 VSS 0.81911f
C1326 vgp.n236 VSS 0.37097f
C1327 vgp.n237 VSS 0.04088f
C1328 vgp.n238 VSS 0.01619f
C1329 vgp.n239 VSS 0.10568f
C1330 vgp.n240 VSS 0.01117f
C1331 vgp.n241 VSS 0.01739f
C1332 vgp.t13 VSS 0.81911f
C1333 vgp.n243 VSS 0.37097f
C1334 vgp.n244 VSS 0.03335f
C1335 vgp.n245 VSS 0.0486f
C1336 vgp.n246 VSS 0.01117f
C1337 vgp.n247 VSS 0.01123f
C1338 vgp.n248 VSS 0.01117f
C1339 vgp.n249 VSS 0.01971f
C1340 vgp.n250 VSS 0.01117f
C1341 vgp.n251 VSS 0.01971f
C1342 vgp.n252 VSS 0.02878f
C1343 vgp.t12 VSS 1.63821f
C1344 vgp.n253 VSS 0.70556f
C1345 vgp.n254 VSS 0.02878f
C1346 vgp.n255 VSS 0.11678f
C1347 vgp.n256 VSS 0.04997f
C1348 vgp.n257 VSS 0.01117f
C1349 vgp.n258 VSS 0.01218f
C1350 vgp.n259 VSS 0.01117f
C1351 vgp.n260 VSS 0.01739f
C1352 vgp.n261 VSS 0.01117f
C1353 vgp.n262 VSS 0.01971f
C1354 vgp.n263 VSS 0.02878f
C1355 vgp.t11 VSS 1.63821f
C1356 vgp.n264 VSS 0.70556f
C1357 vgp.n265 VSS 0.02878f
C1358 vgp.n266 VSS 0.04997f
C1359 vgp.n267 VSS 0.04997f
C1360 vgp.n268 VSS 0.01117f
C1361 vgp.n269 VSS 0.01123f
C1362 vgp.n270 VSS 0.01117f
C1363 vgp.n271 VSS 0.01834f
C1364 vgp.n272 VSS 0.01117f
C1365 vgp.n273 VSS 0.01971f
C1366 vgp.n274 VSS 0.02878f
C1367 vgp.t10 VSS 1.63821f
C1368 vgp.n275 VSS 0.70556f
C1369 vgp.n276 VSS 0.02878f
C1370 vgp.n277 VSS 0.04997f
C1371 vgp.n278 VSS 0.04997f
C1372 vgp.n279 VSS 0.01117f
C1373 vgp.n280 VSS 0.01739f
C1374 vgp.n281 VSS 0.01117f
C1375 vgp.n282 VSS 0.01218f
C1376 vgp.n283 VSS 0.01117f
C1377 vgp.n284 VSS 0.01971f
C1378 vgp.n285 VSS 0.02878f
C1379 vgp.t9 VSS 1.63821f
C1380 vgp.n286 VSS 0.70556f
C1381 vgp.n287 VSS 0.02878f
C1382 vgp.n288 VSS 0.04997f
C1383 vgp.n289 VSS 0.04997f
C1384 vgp.n290 VSS 0.01117f
C1385 vgp.n291 VSS 0.01971f
C1386 vgp.n292 VSS 0.01117f
C1387 vgp.n293 VSS 0.01971f
C1388 vgp.n294 VSS 0.01117f
C1389 vgp.n295 VSS 0.01561f
C1390 vgp.n296 VSS 0.02878f
C1391 vgp.t8 VSS 1.63821f
C1392 vgp.n297 VSS 0.70556f
C1393 vgp.n298 VSS 0.02878f
C1394 vgp.n299 VSS 0.04422f
C1395 vgp.n300 VSS 0.04997f
C1396 vgp.n301 VSS 0.01117f
C1397 vgp.n302 VSS 0.01971f
C1398 vgp.n303 VSS 0.01117f
C1399 vgp.n304 VSS 0.01218f
C1400 vgp.n305 VSS 0.01117f
C1401 vgp.n306 VSS 0.01739f
C1402 vgp.n307 VSS 0.02878f
C1403 vgp.t7 VSS 1.63821f
C1404 vgp.n308 VSS 0.70556f
C1405 vgp.n309 VSS 0.02878f
C1406 vgp.n310 VSS 0.04997f
C1407 vgp.n311 VSS 0.04997f
C1408 vgp.n312 VSS 0.01117f
C1409 vgp.n313 VSS 0.01218f
C1410 vgp.n314 VSS 0.01117f
C1411 vgp.n315 VSS 0.01739f
C1412 vgp.n316 VSS 0.01117f
C1413 vgp.n317 VSS 0.01971f
C1414 vgp.n318 VSS 0.02878f
C1415 vgp.t6 VSS 1.63821f
C1416 vgp.n319 VSS 0.70556f
C1417 vgp.n320 VSS 0.02878f
C1418 vgp.n321 VSS 0.04997f
C1419 vgp.n322 VSS 0.01131f
C1420 vgp.n323 VSS 0.01208f
C1421 vgp.n324 VSS 0.01971f
C1422 vgp.n325 VSS 0.01117f
C1423 vgp.n326 VSS 0.01971f
C1424 vgp.t5 VSS 1.63821f
C1425 vgp.n327 VSS 0.70706f
C1426 vgp.n328 VSS 0.02878f
C1427 vgp.n329 VSS 0.04997f
C1428 vgp.n330 VSS 0.04288f
C1429 vgp.t1 VSS 0.1426f
C1430 VDD.t35 VSS 0.02415f
C1431 VDD.n13 VSS 0.03113f
C1432 VDD.n30 VSS 0.25953f
C1433 VDD.n43 VSS 0.01796f
C1434 VDD.t8 VSS 0.04025f
C1435 VDD.t5 VSS 0.04025f
C1436 VDD.n67 VSS 0.19057f
C1437 VDD.n71 VSS 0.19057f
C1438 VDD.n83 VSS 0.19057f
C1439 VDD.n95 VSS 0.19057f
C1440 VDD.n107 VSS 0.18216f
C1441 VDD.t23 VSS 0.09528f
C1442 VDD.n120 VSS 0.19057f
C1443 VDD.n130 VSS 0.1205f
C1444 VDD.t27 VSS 0.09528f
C1445 VDD.n142 VSS 0.19057f
C1446 VDD.t28 VSS 0.04025f
C1447 VDD.n174 VSS 0.25696f
C1448 VDD.n191 VSS 0.01796f
C1449 VDD.n226 VSS 0.19057f
C1450 VDD.n233 VSS 0.10929f
C1451 VDD.n241 VSS 0.19057f
C1452 VDD.t7 VSS 0.09528f
C1453 VDD.n248 VSS 0.19057f
C1454 VDD.n255 VSS 0.19057f
C1455 VDD.t34 VSS 0.09528f
C1456 VDD.n268 VSS 0.19057f
C1457 VDD.n269 VSS 0.14293f
C1458 VDD.n276 VSS 0.18356f
C1459 VDD.n286 VSS 1.00958f
C1460 VDD.n389 VSS 0.09528f
C1461 VDD.n394 VSS 0.01147f
C1462 VDD.n433 VSS 0.01796f
C1463 VDD.n438 VSS 0.0143f
C1464 VDD.n439 VSS 0.02597f
C1465 VDD.n445 VSS 0.19057f
C1466 VDD.n457 VSS 0.19057f
C1467 VDD.n468 VSS 0.14293f
C1468 VDD.n479 VSS 0.19057f
C1469 VDD.n492 VSS 0.19057f
C1470 VDD.n503 VSS 0.17655f
C1471 VDD.n515 VSS 0.0143f
C1472 VDD.n516 VSS 0.02597f
C1473 VDD.n522 VSS 0.19057f
C1474 VDD.n523 VSS 0.19057f
C1475 VDD.n533 VSS 0.19057f
C1476 VDD.t10 VSS 0.04025f
C1477 VDD.t24 VSS 0.04025f
C1478 VDD.n618 VSS 0.01796f
C1479 VDD.n661 VSS 0.01796f
C1480 VDD.n663 VSS 0.03771f
C1481 VDD.n666 VSS 0.08049f
C1482 VDD.n669 VSS 0.0143f
C1483 VDD.n670 VSS 0.02597f
C1484 VDD.n709 VSS 0.19057f
C1485 VDD.n719 VSS 0.19057f
C1486 VDD.n731 VSS 0.18776f
C1487 VDD.t12 VSS 0.09528f
C1488 VDD.n741 VSS 0.19057f
C1489 VDD.n748 VSS 0.02125f
C1490 VDD.n754 VSS 0.03673f
C1491 VDD.n755 VSS 0.19057f
C1492 VDD.n757 VSS 0.18105f
C1493 VDD.n758 VSS 0.01237f
C1494 VDD.n766 VSS 0.07395f
C1495 VDD.n778 VSS 0.1581f
C1496 VDD.n809 VSS 0.1734f
C1497 VDD.n824 VSS 0.02125f
C1498 VDD.n831 VSS 0.1734f
C1499 VDD.t19 VSS 0.11475f
C1500 VDD.n841 VSS 0.1734f
C1501 VDD.n843 VSS 0.1734f
C1502 VDD.t3 VSS 0.11475f
C1503 VDD.n854 VSS 0.1734f
C1504 VDD.n869 VSS 0.1734f
C1505 VDD.t2 VSS 0.05865f
C1506 VDD.n879 VSS 0.1734f
C1507 VDD.n881 VSS 0.1734f
C1508 VDD.n894 VSS 0.1734f
C1509 VDD.n895 VSS 0.1734f
C1510 VDD.n897 VSS 0.1734f
C1511 VDD.n908 VSS 0.02125f
C1512 VDD.n915 VSS 0.1734f
C1513 VDD.n917 VSS 0.13005f
C1514 VDD.t17 VSS 0.05865f
C1515 VDD.n926 VSS 0.1581f
C1516 VDD.n927 VSS 0.1734f
C1517 VDD.n929 VSS 0.1734f
C1518 VDD.n939 VSS 0.1734f
C1519 VDD.t1 VSS 0.11475f
C1520 VDD.n953 VSS 0.1734f
C1521 VDD.n955 VSS 0.1734f
C1522 VDD.t0 VSS 0.11475f
C1523 VDD.n970 VSS 0.1734f
C1524 VDD.n981 VSS 0.1734f
C1525 VDD.n982 VSS 0.1734f
C1526 VDD.n984 VSS 0.1734f
C1527 VDD.n994 VSS 0.01334f
C1528 VDD.n997 VSS 0.1173f
C1529 VDD.n999 VSS 0.1734f
C1530 VDD.n1012 VSS 0.1734f
C1531 VDD.n1013 VSS 0.1734f
C1532 VDD.n1015 VSS 0.1734f
C1533 VDD.n1023 VSS 0.01257f
C1534 VDD.n1027 VSS 0.06569f
C1535 VDD.n1028 VSS 0.13005f
C1536 VDD.n1030 VSS 0.09355f
C1537 VDD.n1031 VSS 0.10581f
C1538 VDD.n1032 VSS 0.14479f
C1539 VDD.n1041 VSS 0.18934f
C1540 VDD.n1053 VSS 0.18934f
C1541 VDD.t15 VSS 0.02415f
C1542 VDD.n1099 VSS 0.1565f
C1543 VDD.n1112 VSS 0.01796f
C1544 VDD.n1134 VSS 0.01738f
C1545 VDD.n1140 VSS 0.1734f
C1546 VDD.n1141 VSS 0.1734f
C1547 VDD.t29 VSS 0.04025f
C1548 VDD.n1187 VSS 0.01796f
C1549 VDD.n1242 VSS 0.19057f
C1550 VDD.n1249 VSS 0.01499f
C1551 VDD.n1250 VSS 0.01687f
C1552 VDD.t13 VSS 0.02415f
C1553 VDD.n1303 VSS 0.01796f
C1554 VDD.n1309 VSS 0.07244f
C1555 VDD.n1328 VSS 0.19978f
C1556 VDD.n1342 VSS 0.01796f
C1557 VDD.n1359 VSS 0.1734f
C1558 VDD.n1370 VSS 0.1734f
C1559 VDD.n1371 VSS 0.1734f
C1560 VDD.n1379 VSS 0.1479f
C1561 VDD.n1380 VSS 0.1734f
C1562 VDD.n1389 VSS 0.1734f
C1563 VDD.n1390 VSS 0.15555f
C1564 VDD.n1397 VSS 0.01499f
C1565 VDD.n1398 VSS 0.01687f
C1566 VDD.t22 VSS 0.02415f
C1567 VDD.n1450 VSS 0.01796f
C1568 VDD.n1456 VSS 0.14328f
C1569 VDD.n1475 VSS 0.14826f
C1570 VDD.n1476 VSS 0.15393f
C1571 VDD.n1492 VSS 0.01796f
C1572 VDD.t6 VSS 0.04025f
C1573 VDD.n1538 VSS 0.08049f
C1574 VDD.n1546 VSS 0.01796f
C1575 VDD.n1551 VSS 0.02191f
C1576 VDD.n1552 VSS 0.01923f
C1577 VDD.n1558 VSS 0.1734f
C1578 VDD.n1564 VSS 0.01474f
C1579 VDD.n1570 VSS 0.1275f
C1580 VDD.n1571 VSS 0.1734f
C1581 VDD.t21 VSS 0.04025f
C1582 VDD.t20 VSS 0.04025f
C1583 VDD.n1626 VSS 0.01796f
C1584 VDD.n1674 VSS 0.01796f
C1585 VDD.n1680 VSS 0.08049f
C1586 VDD.n1683 VSS 0.01687f
C1587 VDD.n1685 VSS 0.01499f
C1588 VDD.n1691 VSS 0.1734f
C1589 VDD.n1700 VSS 0.1734f
C1590 VDD.n1701 VSS 0.1734f
C1591 VDD.n1714 VSS 0.1734f
C1592 VDD.n1722 VSS 0.1734f
C1593 VDD.n1723 VSS 0.14535f
C1594 VDD.n1727 VSS 0.1581f
C1595 VDD.n1728 VSS 0.1734f
C1596 VDD.n1745 VSS 0.1581f
C1597 VDD.n1746 VSS 0.05865f
C1598 VDD.n1862 VSS 0.01295f
C1599 VDD.n1863 VSS 0.01296f
C1600 VDD.t16 VSS 0.05865f
C1601 VDD.n1867 VSS 0.17085f
C1602 VDD.n1888 VSS 0.01499f
C1603 VDD.n1889 VSS 0.01687f
C1604 VDD.t11 VSS 0.04025f
C1605 VDD.t31 VSS 0.04025f
C1606 VDD.n1944 VSS 0.01796f
C1607 VDD.n1946 VSS 0.03771f
C1608 VDD.n1949 VSS 0.08049f
C1609 VDD.n1968 VSS 0.15393f
C1610 VDD.n1982 VSS 0.01796f
C1611 VDD.t30 VSS 0.02415f
C1612 VDD.n2043 VSS 0.01796f
C1613 VDD.n2047 VSS 0.15616f
C1614 VDD.n2066 VSS 0.11452f
C1615 VDD.n2080 VSS 0.01796f
C1616 VDD.n2087 VSS 0.02889f
C1617 VDD.t33 VSS 0.02415f
C1618 VDD.n2108 VSS 0.01976f
C1619 VDD.n2150 VSS 0.01796f
C1620 VDD.n2152 VSS 0.02164f
C1621 VDD.n2155 VSS 0.07244f
C1622 VDD.n2174 VSS 0.11194f
C1623 VDD.n2200 VSS 0.58923f
C1624 VDD.n2226 VSS 0.01796f
C1625 VDD.n2244 VSS 0.09467f
C1626 VDD.n2293 VSS 0.01066f
C1627 VDD.n2299 VSS 0.09606f
C1628 VDD.n2300 VSS 0.18934f
C1629 VDD.n2301 VSS 0.18934f
C1630 VDD.n2309 VSS 0.01096f
C1631 VDD.n2320 VSS 0.01096f
C1632 VDD.n2326 VSS 2.01684f
C1633 VDD.n2327 VSS 0.18934f
C1634 VDD.n2328 VSS 0.18934f
C1635 VDD.n2337 VSS 0.18934f
C1636 VDD.n2410 VSS 0.18795f
C1637 VDD.n2417 VSS 0.0146f
C1638 VDD.n2418 VSS 0.01649f
C1639 VDD.n2421 VSS 0.07244f
C1640 VDD.n2429 VSS 0.01796f
C1641 VDD.n2434 VSS 0.02164f
C1642 VDD.n2435 VSS 0.035f
C1643 VDD.n2441 VSS 0.18934f
C1644 VDD.n2442 VSS 0.10581f
C1645 VDD.t14 VSS 0.09467f
C1646 VDD.n2443 VSS 0.1782f
C1647 VDD.n2452 VSS 0.18934f
C1648 VDD.n2461 VSS 0.04985f
C1649 VDD.t32 VSS 0.13694f
C1650 VDD.n2462 VSS 0.07421f
C1651 VDD.n2463 VSS 0.18105f
C1652 VDD.n2471 VSS 0.1734f
C1653 VDD.n2472 VSS 0.1734f
C1654 VDD.n2481 VSS 0.1734f
C1655 VDD.n2482 VSS 0.1734f
C1656 VDD.n2491 VSS 0.1734f
C1657 VDD.n2492 VSS 0.1734f
C1658 VDD.n2501 VSS 0.1734f
C1659 VDD.n2502 VSS 0.07395f
C1660 VDD.n2511 VSS 0.1734f
C1661 VDD.n2512 VSS 0.1734f
C1662 VDD.n2521 VSS 0.0867f
C1663 VDD.n2522 VSS 0.1734f
C1664 VDD.n2531 VSS 0.1734f
C1665 VDD.n2532 VSS 0.1734f
C1666 VDD.n2541 VSS 0.1734f
C1667 VDD.n2542 VSS 0.1734f
C1668 VDD.n2548 VSS 0.01937f
C1669 VDD.n2554 VSS 0.11475f
C1670 VDD.t18 VSS 0.11475f
C1671 VDD.n2555 VSS 0.1173f
C1672 VDD.n2564 VSS 0.1734f
C1673 VDD.n2565 VSS 0.1734f
C1674 VDD.n2574 VSS 0.16065f
C1675 VDD.n2575 VSS 0.1734f
C1676 VDD.n2584 VSS 0.1734f
C1677 VDD.n2585 VSS 0.08415f
C1678 VDD.n2594 VSS 0.1734f
C1679 VDD.n2595 VSS 0.1734f
C1680 VDD.n2604 VSS 0.0765f
C1681 VDD.n2605 VSS 0.1734f
C1682 VDD.n2611 VSS 0.01937f
C1683 VDD.n2617 VSS 0.1734f
C1684 VDD.n2618 VSS 0.1734f
C1685 VDD.n2685 VSS 0.11475f
C1686 VDD.n2695 VSS 0.03142f
C1687 VDD.n2696 VSS 0.14437f
C1688 VDD.n2697 VSS 0.09203f
C1689 VDD.n2698 VSS 0.17095f
C1690 VDD.n2705 VSS 0.01937f
C1691 VDD.n2711 VSS 0.19057f
C1692 VDD.n2712 VSS 0.19057f
C1693 VDD.n2713 VSS 0.09809f
C1694 VDD.n2722 VSS 0.19057f
C1695 VDD.n2723 VSS 0.19057f
C1696 VDD.n2724 VSS 0.19057f
C1697 VDD.n2732 VSS 0.19057f
C1698 VDD.n2733 VSS 0.13171f
C1699 VDD.t25 VSS 0.09528f
C1700 VDD.n2734 VSS 0.15413f
C1701 VDD.n2743 VSS 0.19057f
C1702 VDD.n2749 VSS 0.02597f
C1703 VDD.n2750 VSS 0.0143f
C1704 VDD.t26 VSS 0.04025f
C1705 VDD.n2788 VSS 0.08049f
C1706 VDD.n2796 VSS 0.01796f
C1707 VDD.n2801 VSS 0.02125f
C1708 VDD.n2802 VSS 0.01937f
C1709 VDD.n2808 VSS 0.19057f
C1710 VDD.n2809 VSS 0.19057f
C1711 VDD.n2810 VSS 0.16534f
C1712 VDD.n2819 VSS 0.19057f
C1713 VDD.n2820 VSS 0.19057f
C1714 VDD.n2821 VSS 0.19057f
C1715 VDD.n2830 VSS 0.19057f
C1716 VDD.n2831 VSS 0.19057f
C1717 VDD.n2832 VSS 0.10369f
C1718 VDD.n2840 VSS 0.19057f
C1719 VDD.n2841 VSS 0.19057f
C1720 VDD.n2842 VSS 0.19057f
C1721 VDD.n2851 VSS 0.19057f
C1722 VDD.n2852 VSS 0.13732f
C1723 VDD.t9 VSS 0.09528f
C1724 VDD.n2853 VSS 0.14853f
C1725 VDD.n2862 VSS 0.19057f
C1726 VDD.n2863 VSS 0.19057f
C1727 VDD.n2864 VSS 0.19057f
C1728 VDD.n2873 VSS 0.17095f
C1729 VDD.t4 VSS 0.09528f
C1730 VDD.n2874 VSS 0.1149f
C1731 VDD.n2875 VSS 0.19057f
C1732 VDD.n2881 VSS 0.01937f
C1733 VDD.n2923 VSS 0.01796f
C1734 VDD.n2925 VSS 0.02125f
C1735 VDD.n2928 VSS 0.08049f
C1736 VDD.n2947 VSS 0.25696f
C1737 VDD.n2948 VSS 0.36669f
C1738 VDD.n2972 VSS 0.01796f
C1739 VDD.n2974 VSS 0.02125f
C1740 VDD.n2977 VSS 0.07244f
C1741 VO_ota.t10 VSS 0.05229f
C1742 VO_ota.n13 VSS 0.01098f
C1743 VO_ota.n17 VSS 0.014f
C1744 VO_ota.n19 VSS 0.01016f
C1745 VO_ota.n20 VSS 0.01673f
C1746 VO_ota.n22 VSS 0.01098f
C1747 VO_ota.n23 VSS 0.01698f
C1748 VO_ota.t6 VSS 0.18987p
C1749 VO_ota.t16 VSS 0.05229f
C1750 VO_ota.t3 VSS 0.05229f
C1751 VO_ota.n90 VSS 0.02134f
C1752 VO_ota.n91 VSS 0.01044f
C1753 VO_ota.n93 VSS 0.10458f
C1754 VO_ota.n95 VSS 0.01098f
C1755 VO_ota.n96 VSS 0.02027f
C1756 VO_ota.n97 VSS 0.01341f
C1757 VO_ota.n98 VSS 0.01673f
C1758 VO_ota.n101 VSS 0.03025f
C1759 VO_ota.n102 VSS 0.03192f
C1760 VO_ota.n103 VSS 0.6094f
C1761 VO_ota.t1 VSS 0.05229f
C1762 VO_ota.t4 VSS 0.05229f
C1763 VO_ota.n171 VSS 0.02134f
C1764 VO_ota.n172 VSS 0.01044f
C1765 VO_ota.n174 VSS 0.10458f
C1766 VO_ota.n176 VSS 0.01098f
C1767 VO_ota.n177 VSS 0.02027f
C1768 VO_ota.n178 VSS 0.014f
C1769 VO_ota.n180 VSS 0.01016f
C1770 VO_ota.n181 VSS 0.01673f
C1771 VO_ota.n183 VSS 0.01098f
C1772 VO_ota.n184 VSS 0.01698f
C1773 VO_ota.n185 VSS 0.03192f
C1774 VO_ota.n186 VSS 0.10094f
C1775 VO_ota.t9 VSS 0.05229f
C1776 VO_ota.t11 VSS 0.05229f
C1777 VO_ota.n254 VSS 0.02134f
C1778 VO_ota.n255 VSS 0.01044f
C1779 VO_ota.n257 VSS 0.10458f
C1780 VO_ota.n259 VSS 0.01098f
C1781 VO_ota.n260 VSS 0.02027f
C1782 VO_ota.n261 VSS 0.01791f
C1783 VO_ota.n262 VSS 0.09107f
C1784 VO_ota.n263 VSS 0.14578f
C1785 VO_ota.n264 VSS 0.04215f
C1786 VO_ota.n265 VSS 0.02027f
C1787 VO_ota.n281 VSS 0.01277f
C1788 VO_ota.n282 VSS 0.02134f
C1789 VO_ota.t5 VSS 0.05229f
C1790 VO_ota.n305 VSS 0.10458f
C1791 VGN.t0 VSS 0.24405f
C1792 VGN.n2 VSS 0.10393f
C1793 VGN.n6 VSS 0.01173f
C1794 VGN.n7 VSS 0.23118f
C1795 VIN_ota.n1 VSS 0.01389f
C1796 VIN_ota.t3 VSS 1.06084f
C1797 VIN_ota.n2 VSS 0.06678f
C1798 VIN_ota.n3 VSS 0.01389f
C1799 VIN_ota.t0 VSS 1.06084f
C1800 VIN_ota.n4 VSS 0.02029f
C1801 VIN_ota.n5 VSS 0.47537f
C1802 VIN_ota.n7 VSS 0.08861f
C1803 VIN_ota.n8 VSS 0.10972f
C1804 VIN_ota.n9 VSS 0.02034f
C1805 VIN_ota.t1 VSS 1.06084f
C1806 VIN_ota.n10 VSS 0.47537f
C1807 VIN_ota.n12 VSS 0.01389f
C1808 VIN_ota.n14 VSS 0.1724f
C1809 VIN_ota.n15 VSS 0.37372f
C1810 VIN_ota.n17 VSS 0.01389f
C1811 VIN_ota.t2 VSS 1.06084f
C1812 VIN_ota.n18 VSS 0.02036f
C1813 VIN_ota.n19 VSS 0.47537f
C1814 VIN_ota.n21 VSS 0.18271f
C1815 VIN_ota.n22 VSS 0.43086f
C1816 VIN_ota.n23 VSS 0.21486f
C1817 VIN_ota.n25 VSS 0.47537f
C1818 VIN_ota.n26 VSS 0.02036f
C1819 VIP_ota.n1 VSS 0.01383f
C1820 VIP_ota.t0 VSS 1.05662f
C1821 VIP_ota.n2 VSS 0.01193f
C1822 VIP_ota.n3 VSS 0.04299f
C1823 VIP_ota.n5 VSS 0.01383f
C1824 VIP_ota.t3 VSS 1.05662f
C1825 VIP_ota.n7 VSS 0.47347f
C1826 VIP_ota.n8 VSS 0.02011f
C1827 VIP_ota.n9 VSS 0.02451f
C1828 VIP_ota.n10 VSS 0.06871f
C1829 VIP_ota.n11 VSS 0.14145f
C1830 VIP_ota.n12 VSS 0.02976f
C1831 VIP_ota.n13 VSS 0.0201f
C1832 VIP_ota.n14 VSS 0.01383f
C1833 VIP_ota.t2 VSS 1.05662f
C1834 VIP_ota.n15 VSS 0.47347f
C1835 VIP_ota.n17 VSS 0.04274f
C1836 VIP_ota.n18 VSS 0.02792f
C1837 VIP_ota.n19 VSS 0.02976f
C1838 VIP_ota.n20 VSS 0.14789f
C1839 VIP_ota.n21 VSS 0.14789f
C1840 VIP_ota.n22 VSS 0.02976f
C1841 VIP_ota.n23 VSS 0.02028f
C1842 VIP_ota.n24 VSS 0.03989f
C1843 VIP_ota.t1 VSS 1.05662f
C1844 VIP_ota.n25 VSS 0.47347f
C1845 VIP_ota.n27 VSS 0.01383f
C1846 VIP_ota.n28 VSS 0.03071f
C1847 VIP_ota.n29 VSS 0.02976f
C1848 VIP_ota.n30 VSS 0.14202f
C1849 VIP_ota.n31 VSS 0.06881f
C1850 VIP_ota.n32 VSS 0.02832f
C1851 VIP_ota.n33 VSS 0.0201f
C1852 VIP_ota.n34 VSS 0.47347f
.ends
