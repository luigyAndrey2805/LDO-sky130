* test 2 sweeps
.option ngbehavior=ps
.lib /foss/pdks/sky130A/libs.tech/ngspice/sky130.lib.spice tt
XMplvt vo_p vgp vdd vdd sky130_fd_pr__pfet_01v8_lvt L=0.35 W=10 nf=1
XMnlvt vo_n vgn 0 0 sky130_fd_pr__nfet_01v8_lvt L=0.35 W=10 nf=1
Vdd vdd 0 1.8
Vgp vgp 0 0.6
Vgn vgn 0 0.6
Vo_p vo_p 0 1.2
Vo_n vo_n 0 0.6

.control
  set filetype=ascii
  save @m.xMplvt.msky130_fd_pr__pfet_01v8_lvt[gm] @m.xMnlvt.msky130_fd_pr__nfet_01v8_lvt[gm]

  * Barrido 1: PMOS
  dc Vgp 0 1.8 0.01

  * Barrido 2: NMOS
  dc Vgn 0 1.8 0.01

  * Guardar ambos plots
  setplot dc1
  write caracterizador_pmos.raw all
  setplot dc2
  write caracterizador_nmos.raw all
.endc
.end
