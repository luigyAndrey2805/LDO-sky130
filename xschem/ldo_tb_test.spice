** ldo_tb_test.spice
.lib /foss/pdks/sky130A/libs.tech/ngspice/sky130.lib.spice tt

.param VDD = 1.8
.param VREF = 0.6
.param VIN = 1.8
.param RL = 100
.param CL = 1u

* Testbench LDO con inyección AC directa en VIP_ota para medir Ganancia de Lazo (Loop Gain)
x1 vi vo net2 net1 0 LDO_test
V1 net2 0 {VDD}
V2 net1 0 {VREF}
V3 vi 0 {VIN}
R1 vo 0 {RL}
C1 vo 0 {CL}

* Inyección AC en el nodo de realimentación (VIP_ota)
Vac ac_in 0 ac 1
Cac ac_in x1.net3 1F

.control
set filetype=ascii
op
ac dec 10 1 1G

* Convertir fase a grados multiplicando por 180/pi
let fase_deg = vp(vo) * 180 / pi
let target_3db = vdb(vo)[0] - 3.0
meas ac f3db WHEN vdb(vo) = target_3db
meas ac ugb WHEN vdb(vo) = 0.0
meas ac fase_ugb FIND fase_deg WHEN vdb(vo) = 0.0
let margen_fase = 180 + fase_ugb
print f3db ugb fase_ugb margen_fase
.endc

.subckt LDO_test VIN VOUT VDD Vref VSS
x1 VDD net2 Vref net3 net1 VSS OTA
I0 VDD net1 10u
XM1 VOUT net2 VIN VDD sky130_fd_pr__pfet_01v8_lvt L=0.35 W=1000 nf=50 ad=145 as=150.8 pd=1014.5 ps=1055.08 nrd=0.00029 nrs=0.00029 sa=0 sb=0 sd=0 mult=5 m=5
XR1 Vre VOUT VDD sky130_fd_pr__res_iso_pw W=2.65 L=2.65
XR2 VSS Vre VDD sky130_fd_pr__res_iso_pw W=2.65 L=2.65
L4 Vre net3 1G
.ends

.subckt OTA VDD VO_ota VIN_ota VIP_ota Iref VSS
XMr Iref Iref VSS VSS sky130_fd_pr__nfet_01v8 L=0.5 W=0.5 nf=1 ad=0.145 as=0.145 pd=1.58 ps=1.58 nrd=0.58 nrs=0.58 sa=0 sb=0 sd=0 mult=1
XMo VO_ota VO_ota1 VDD VDD sky130_fd_pr__pfet_01v8 L=0.5 W=20 nf=1 ad=5.8 as=5.8 pd=40.58 ps=40.58 nrd=0.0145 nrs=0.0145 sa=0 sb=0 sd=0 mult=1
XMrc1 Vtail Iref VSS VSS sky130_fd_pr__nfet_01v8 L=0.5 W=2 nf=1 ad=0.58 as=0.58 pd=4.58 ps=4.58 nrd=0.145 nrs=0.145 sa=0 sb=0 sd=0 mult=1
XMc2 VO_ota Iref VSS VSS sky130_fd_pr__nfet_01v8 L=0.5 W=1 nf=1 ad=0.29 as=0.29 pd=2.58 ps=2.58 nrd=0.29 nrs=0.29 sa=0 sb=0 sd=0 mult=1
XMn VGP VIN_ota Vtail VSS sky130_fd_pr__nfet_01v8 L=0.5 W=40 nf=1 ad=11.6 as=11.6 pd=80.58 ps=80.58 nrd=0.00725 nrs=0.00725 sa=0 sb=0 sd=0 mult=1
XMp VO_ota1 VIP_ota Vtail VSS sky130_fd_pr__nfet_01v8 L=0.5 W=40 nf=1 ad=11.6 as=11.6 pd=80.58 ps=80.58 nrd=0.00725 nrs=0.00725 sa=0 sb=0 sd=0 mult=1
XMpr VO_ota1 VGP VDD VDD sky130_fd_pr__pfet_01v8 L=0.5 W=40 nf=1 ad=11.6 as=11.6 pd=80.58 ps=80.58 nrd=0.00725 nrs=0.00725 sa=0 sb=0 sd=0 mult=1
XMnr VGP VGP VDD VDD sky130_fd_pr__pfet_01v8 L=0.5 W=40 nf=1 ad=11.6 as=11.6 pd=80.58 ps=80.58 nrd=0.00725 nrs=0.00725 sa=0 sb=0 sd=0 mult=1
XR1 VO_ota1 net1 VDD sky130_fd_pr__res_high_po W=0.4 L=22.8 mult=1
XC1 VO_ota net1 sky130_fd_pr__cap_mim_m3_2 W=35 L=35 MF=1
.ends

.end
