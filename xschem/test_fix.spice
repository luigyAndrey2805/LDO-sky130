** Netlist OTA_tbtran fix
.lib /foss/pdks/sky130A/libs.tech/ngspice/sky130.lib.spice tt

.param VDD = 1.8
.param VCM = 1.2
.param VAC = 1
.param deltavin = 50m
.param tsim = 2m

x1 net1 vo vin vip net2 0 OTA
V1 net1 0 {VDD}
I0 net1 net2 10u
V2 vin 0 {VCM}
V3 vip vin PWL(0 {-deltavin} {tsim} {deltavin})

.control
set filetype=ascii
op
write OTA_op.raw all

tran 1u {tsim}
write OTA_trans.raw all
quit
.endc

.subckt OTA VDD VO_ota VIN_ota VIP_ota Iref VSS
XMr Iref Iref VSS VSS sky130_fd_pr__nfet_01v8 L=0.15 W=1 nf=1 ad=0.29 as=0.29 pd=2.58 ps=2.58 nrd=0.29 nrs=0.29 sa=0 sb=0 sd=0 mult=1
XMo VO_ota VGP VDD VDD sky130_fd_pr__pfet_01v8 L=0.15 W=1 nf=1 ad=0.29 as=0.29 pd=2.58 ps=2.58 nrd=0.29 nrs=0.29 sa=0 sb=0 sd=0 mult=1
XMrc1 Vtail Iref VSS VSS sky130_fd_pr__nfet_01v8 L=0.15 W=1 nf=1 ad=0.29 as=0.29 pd=2.58 ps=2.58 nrd=0.29 nrs=0.29 sa=0 sb=0 sd=0 mult=1
XMc2 VO_ota Iref VSS VSS sky130_fd_pr__nfet_01v8 L=0.15 W=1 nf=1 ad=0.29 as=0.29 pd=2.58 ps=2.58 nrd=0.29 nrs=0.29 sa=0 sb=0 sd=0 mult=1
XMn VGP VIN_ota Vtail VSS sky130_fd_pr__nfet_01v8 L=0.15 W=1 nf=1 ad=0.29 as=0.29 pd=2.58 ps=2.58 nrd=0.29 nrs=0.29 sa=0 sb=0 sd=0 mult=1
XMp VO_ota VIP_ota Vtail VSS sky130_fd_pr__nfet_01v8 L=0.15 W=1 nf=1 ad=0.29 as=0.29 pd=2.58 ps=2.58 nrd=0.29 nrs=0.29 sa=0 sb=0 sd=0 mult=1
XMpr VO_ota VGP VDD VDD sky130_fd_pr__pfet_01v8 L=0.15 W=1 nf=1 ad=0.29 as=0.29 pd=2.58 ps=2.58 nrd=0.29 nrs=0.29 sa=0 sb=0 sd=0 mult=1
XMnr VGP VGP VDD VDD sky130_fd_pr__pfet_01v8 L=0.15 W=1 nf=1 ad=0.29 as=0.29 pd=2.58 ps=2.58 nrd=0.29 nrs=0.29 sa=0 sb=0 sd=0 mult=1
XR1 VO_ota net_c VSS sky130_fd_pr__res_iso_pw W=2.65 L=2.65
XC1 net_c VO_ota sky130_fd_pr__cap_mim_m3_2 W=10 L=10 MF=1
.ends
.end
