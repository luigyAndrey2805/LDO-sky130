* Extracted by KLayout with SKY130 LVS runset on : 18/10/2026 22:11

* cell OTA
* pin VO_ota
* pin mnr,vd
* pin VIN_ota
* pin VGN
* pin vmiler
* pin vo1
* pin VIP_ota
* pin vtail
* pin vgp
* pin VDD
* pin VSS
.SUBCKT OTA VO_ota mnr|vd VIN_ota VGN vmiler vo1 VIP_ota vtail vgp VDD VSS
* device instance $1 r0 *1 20.85,-40.02 sky130_fd_pr__model__cap_mim_m4
XC$1 VO_ota vmiler sky130_fd_pr__model__cap_mim_m4 C=4.9952 A=2.4976e+15
+ P=201200000
* device instance $2 m0 *1 5.14,-2.53 sky130_fd_pr__nfet_01v8
XM$2 VSS VGN vgp VSS sky130_fd_pr__nfet_01v8 L=1000000 W=8000000 AS=2.4e+12
+ AD=2.4e+12 PS=16600000 PD=16600000
* device instance $3 r0 *1 5.04,6.675 sky130_fd_pr__pfet_01v8_lvt
XM$3 VDD vgp vgp VDD sky130_fd_pr__pfet_01v8_lvt L=1000000 W=12500000
+ AS=3.4375e+12 AD=3.4375e+12 PS=19850000 PD=19850000
* device instance $5 m0 *1 9.3,-8.68 sky130_fd_pr__nfet_01v8
XM$5 mnr|vd mnr|vd VSS VSS sky130_fd_pr__nfet_01v8 L=1000000 W=6000000
+ AS=1.575e+12 AD=1.575e+12 PS=9600000 PD=9600000
* device instance $6 m0 *1 10.8,-8.68 sky130_fd_pr__nfet_01v8
XM$6 VSS mnr|vd vo1 VSS sky130_fd_pr__nfet_01v8 L=1000000 W=6000000 AS=1.5e+12
+ AD=1.5e+12 PS=8000000 PD=8000000
* device instance $13 m0 *1 9.31,-1.67 sky130_fd_pr__pfet_01v8_lvt
XM$13 mnr|vd VIN_ota vtail VDD sky130_fd_pr__pfet_01v8_lvt L=1000000 W=26000000
+ AS=6.825e+12 AD=6.825e+12 PS=34600000 PD=34600000
* device instance $14 m0 *1 10.81,-1.67 sky130_fd_pr__pfet_01v8_lvt
XM$14 vtail VIP_ota vo1 VDD sky130_fd_pr__pfet_01v8_lvt L=1000000 W=26000000
+ AS=6.5e+12 AD=6.5e+12 PS=28000000 PD=28000000
* device instance $21 r0 *1 9.31,6.705 sky130_fd_pr__pfet_01v8_lvt
XM$21 VDD vgp vtail VDD sky130_fd_pr__pfet_01v8_lvt L=1000000 W=50000000
+ AS=1.359375e+13 AD=1.359375e+13 PS=60600000 PD=60600000
* device instance $29 m0 *1 24.39,0.51 sky130_fd_pr__nfet_01v8
XM$29 VSS vo1 VO_ota VSS sky130_fd_pr__nfet_01v8 L=2000000 W=8000000
+ AS=2.05e+12 AD=2.05e+12 PS=13100000 PD=13100000
* device instance $37 r0 *1 24.39,6.705 sky130_fd_pr__pfet_01v8_lvt
XM$37 VDD vgp VO_ota VDD sky130_fd_pr__pfet_01v8_lvt L=2000000 W=50000000
+ AS=1.28125e+13 AD=1.28125e+13 PS=60350000 PD=60350000
* device instance $48 r90 *1 32.98,-5.85 sky130_fd_pr__res_xhigh_po_0p35
XR$48 vo1 vmiler VSS sky130_fd_pr__res_xhigh_po_0p35 R=518400 L=90720000
+ W=350000 A=3.1752e+13 P=185640000
.ENDS OTA
