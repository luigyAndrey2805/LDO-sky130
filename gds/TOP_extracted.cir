* Extracted by KLayout with SKY130 LVS runset on : 18/10/2026 21:46

* cell vias_gen$33
.SUBCKT vias_gen$33
.ENDS vias_gen$33

* cell TOP
.SUBCKT TOP
* cell instance $1 r0 *1 45.06,1.92
X$1 VO_ota vias_gen$34
* cell instance $2 r0 *1 40.48,3.58
X$2 VO_ota vias_gen$16
* cell instance $3 r0 *1 23.09,3.58
X$3 VDD VO_ota VDD VO_ota VDD VO_ota VDD VO_ota VDD vgp vgp vgp vgp vgp vgp vgp
+ vgp VDD pfet$2
* cell instance $4 r0 *1 25.48,3.58
X$4 VO_ota vias_gen$16
* cell instance $5 r0 *1 35.48,3.58
X$5 VO_ota vias_gen$16
* cell instance $6 r0 *1 30.48,3.58
X$6 VO_ota vias_gen$16
* cell instance $7 r0 *1 25.48,0.01
X$7 VO_ota vias_gen$20
* cell instance $8 m0 *1 23.09,1.01
X$8 VSS VO_ota VSS VO_ota VSS VO_ota VSS VO_ota VSS vo1 vo1 vo1 vo1 vo1 vo1 vo1
+ vo1 VSS nfet$3
* cell instance $9 r0 *1 40.48,0.01
X$9 VO_ota vias_gen$20
* cell instance $10 r0 *1 35.48,0.01
X$10 VO_ota vias_gen$20
* cell instance $11 r0 *1 30.48,0.01
X$11 VO_ota vias_gen$20
* cell instance $12 r0 *1 40.44,2
X$12 VO_ota vias_gen$24
* cell instance $13 r0 *1 30.46,2
X$13 VO_ota vias_gen$24
* cell instance $14 r0 *1 25.44,2
X$14 VO_ota vias_gen$24
* cell instance $15 r0 *1 35.44,2
X$15 VO_ota vias_gen$24
* cell instance $16 r0 *1 -1.45,-68.02
X$16 VO_ota \$18 mim_cap
* cell instance $17 r0 *1 20.28,-3.9
X$17 mnr|vd vias_gen$24
* cell instance $18 r0 *1 14.37,-3.89
X$18 mnr|vd vias_gen$24
* cell instance $19 r0 *1 8.5,-4.92
X$19 mnr|vd vias_gen$18
* cell instance $20 m0 *1 8.51,1.58
X$20 mnr|vd vtail vo1 vtail mnr|vd vtail vo1 vtail mnr|vd VIN_ota VIP_ota
+ VIP_ota VIN_ota VIN_ota VIP_ota VIP_ota VIN_ota VDD pfet$4
* cell instance $21 r0 *1 8.46,-3.89
X$21 mnr|vd vias_gen$24
* cell instance $22 r0 *1 20.3,-4.92
X$22 mnr|vd vias_gen$18
* cell instance $23 r0 *1 14.4,-4.92
X$23 mnr|vd vias_gen$18
* cell instance $24 m0 *1 8.5,-7.93
X$24 mnr|vd VSS vo1 VSS mnr|vd VSS vo1 VSS mnr|vd mnr|vd mnr|vd mnr|vd mnr|vd
+ mnr|vd mnr|vd mnr|vd mnr|vd VSS nfet
* cell instance $25 r0 *1 8.49,-9.43
X$25 mnr|vd vias_gen$21
* cell instance $26 r0 *1 14.39,-9.43
X$26 mnr|vd vias_gen$21
* cell instance $27 r0 *1 20.29,-9.43
X$27 mnr|vd vias_gen$21
* cell instance $28 r0 *1 8.8,-9.96
X$28 mnr|vd vias_gen$32
* cell instance $29 r0 *1 19.3,-9.96
X$29 mnr|vd vias_gen$32
* cell instance $30 r0 *1 16.3,-9.96
X$30 mnr|vd vias_gen$32
* cell instance $31 r0 *1 14.8,-9.97
X$31 mnr|vd vias_gen$32
* cell instance $32 r0 *1 13.3,-9.96
X$32 mnr|vd vias_gen$32
* cell instance $33 r0 *1 11.8,-9.96
X$33 mnr|vd vias_gen$32
* cell instance $34 r0 *1 10.31,-9.96
X$34 mnr|vd vias_gen$32
* cell instance $35 r0 *1 17.81,-9.96
X$35 mnr|vd vias_gen$32
* cell instance $36 r0 *1 13.31,-6.08
X$36 VIN_ota vias_gen$26
* cell instance $37 r0 *1 15.01,-6.09
X$37 VIN_ota vias_gen$26
* cell instance $38 r0 *1 19.3,-6.09
X$38 VIN_ota vias_gen$26
* cell instance $39 r0 *1 9.01,-6.09
X$39 VIN_ota vias_gen$26
* cell instance $40 m0 *1 4.34,1.47
X$40 VSS vgp VGN VSS nfet$4
* cell instance $41 r90 *1 32.98,-8.39
X$41 \$18 \$16 VSS res_poly
* cell instance $42 r90 *1 32.98,-7.12
X$42 \$37 \$16 VSS res_poly
* cell instance $43 r0 *1 23.42,-8.57
X$43 \$18 vias_gen$51
* cell instance $44 r0 *1 23.4,-9.64
X$44 \$18 vias_gen$50
* cell instance $45 r0 *1 23.38,-0.52
X$45 vo1 vias_gen$22
* cell instance $46 r0 *1 30.89,-0.52
X$46 vo1 vias_gen$22
* cell instance $47 r0 *1 28.39,-0.52
X$47 vo1 vias_gen$22
* cell instance $48 r0 *1 25.88,-0.52
X$48 vo1 vias_gen$22
* cell instance $49 r0 *1 33.39,-0.52
X$49 vo1 vias_gen$22
* cell instance $50 r0 *1 35.89,-0.52
X$50 vo1 vias_gen$22
* cell instance $51 r0 *1 38.4,-0.52
X$51 vo1 vias_gen$22
* cell instance $52 r0 *1 23.42,-2.23
X$52 vo1 vias_gen$22
* cell instance $53 r0 *1 40.89,-0.52
X$53 vo1 vias_gen$22
* cell instance $54 r0 *1 11.38,-0.52
X$54 vo1 vias_gen$24
* cell instance $55 r0 *1 17.37,-0.52
X$55 vo1 vias_gen$24
* cell instance $56 r0 *1 11.38,-2.27
X$56 vo1 vias_gen$24
* cell instance $57 r0 *1 17.37,-2.27
X$57 vo1 vias_gen$24
* cell instance $58 r0 *1 17.4,-4.92
X$58 vo1 vias_gen$18
* cell instance $59 r0 *1 11.4,-4.92
X$59 vo1 vias_gen$18
* cell instance $60 r90 *1 32.98,-2.06
X$60 vo1 \$53 VSS res_poly
* cell instance $61 r0 *1 17.39,-9.43
X$61 vo1 vias_gen$21
* cell instance $62 r0 *1 11.39,-9.43
X$62 vo1 vias_gen$21
* cell instance $63 r0 *1 10.31,-5.45
X$63 VIP_ota vias_gen$26
* cell instance $64 r0 *1 18.02,-5.45
X$64 VIP_ota vias_gen$26
* cell instance $65 r0 *1 12.02,-5.45
X$65 VIP_ota vias_gen$26
* cell instance $66 r0 *1 16.3,-5.45
X$66 VIP_ota vias_gen$26
* cell instance $67 r90 *1 32.98,-5.85
X$67 \$37 \$43 VSS res_poly
* cell instance $68 r90 *1 32.98,-4.58
X$68 \$59 \$43 VSS res_poly
* cell instance $69 r0 *1 18.9,3.58
X$69 vtail vias_gen$16
* cell instance $70 r0 *1 8.51,3.58
X$70 VDD vtail VDD vtail VDD vtail VDD vtail VDD vgp vgp vgp vgp vgp vgp vgp
+ vgp VDD pfet
* cell instance $71 r0 *1 15.9,3.58
X$71 vtail vias_gen$16
* cell instance $72 r0 *1 12.9,3.58
X$72 vtail vias_gen$16
* cell instance $73 r0 *1 9.89,3.58
X$73 vtail vias_gen$16
* cell instance $74 r0 *1 12.88,2.85
X$74 vtail vias_gen$24
* cell instance $75 r0 *1 15.88,2.87
X$75 vtail vias_gen$24
* cell instance $76 r0 *1 18.87,2.84
X$76 vtail vias_gen$24
* cell instance $77 r0 *1 9.87,2.85
X$77 vtail vias_gen$24
* cell instance $78 r0 *1 15.9,-4.92
X$78 vtail vias_gen$18
* cell instance $79 r0 *1 18.9,-4.92
X$79 vtail vias_gen$18
* cell instance $80 r0 *1 12.9,-4.92
X$80 vtail vias_gen$18
* cell instance $81 r0 *1 9.9,-4.92
X$81 vtail vias_gen$18
* cell instance $82 r90 *1 32.98,-3.31
X$82 \$59 \$53 VSS res_poly
* cell instance $83 r0 *1 5.63,3.55
X$83 vgp vias_gen$16
* cell instance $84 r0 *1 4.24,3.55
X$84 VDD vgp VDD vgp vgp VDD pfet$6
* cell instance $85 r0 *1 5.62,-6.53
X$85 vgp vias_gen$14
* cell instance $86 r0 *1 42.67,10.99
X$86 VDD vias_gen$56
* cell instance $87 r0 *1 4.2,3.55
X$87 VDD vias_gen$46
* cell instance $88 r0 *1 7,3.55
X$88 VDD vias_gen$46
* cell instance $89 r0 *1 17.37,3.58
X$89 VDD vias_gen$46
* cell instance $90 r0 *1 14.37,3.58
X$90 VDD vias_gen$46
* cell instance $91 r0 *1 42.85,3.58
X$91 VDD vias_gen$46
* cell instance $92 r0 *1 37.95,3.58
X$92 VDD vias_gen$46
* cell instance $93 r0 *1 11.37,3.58
X$93 VDD vias_gen$46
* cell instance $94 r0 *1 8.47,3.57
X$94 VDD vias_gen$46
* cell instance $95 r0 *1 32.95,3.58
X$95 VDD vias_gen$46
* cell instance $96 r0 *1 27.95,3.58
X$96 VDD vias_gen$46
* cell instance $97 r0 *1 23.05,3.58
X$97 VDD vias_gen$46
* cell instance $98 r0 *1 20.27,3.58
X$98 VDD vias_gen$46
* cell instance $99 r0 *1 43.53,2.74
X$99 VDD \$I121 vias_gen
* cell instance $100 r0 *1 3.99,2.43
X$100 VDD vias_gen$48
* cell instance $101 r0 *1 1.42,2.45
X$101 VDD \$I121 vias_gen$4
* cell instance $102 r0 *1 3.44,2.74
X$102 VDD \$I121 vias_gen
* cell instance $103 r0 *1 1.42,11.01
X$103 VDD \$I121 vias_gen$4
* cell instance $104 r0 *1 3.82,10.99
X$104 VDD vias_gen$56
* cell instance $105 r0 *1 6.79,2.45
X$105 VDD vias_gen$48
* cell instance $106 r0 *1 37.73,10.99
X$106 VDD vias_gen$48
* cell instance $107 r0 *1 32.73,10.99
X$107 VDD vias_gen$48
* cell instance $108 r0 *1 27.74,10.99
X$108 VDD vias_gen$48
* cell instance $109 r0 *1 22.86,10.99
X$109 VDD vias_gen$48
* cell instance $110 r0 *1 22.84,2.43
X$110 VDD vias_gen$48
* cell instance $111 r0 *1 8.24,2.43
X$111 VDD vias_gen$48
* cell instance $112 r0 *1 14.16,2.43
X$112 VDD vias_gen$48
* cell instance $113 r0 *1 14.21,10.99
X$113 VDD vias_gen$48
* cell instance $114 r0 *1 11.14,10.99
X$114 VDD vias_gen$48
* cell instance $115 r0 *1 11.18,2.43
X$115 VDD vias_gen$48
* cell instance $116 r0 *1 20.07,2.43
X$116 VDD vias_gen$48
* cell instance $117 r0 *1 8.25,11
X$117 VDD vias_gen$48
* cell instance $118 r0 *1 17.17,10.99
X$118 VDD vias_gen$48
* cell instance $119 r0 *1 20.06,10.99
X$119 VDD vias_gen$48
* cell instance $120 r0 *1 6.75,10.99
X$120 VDD vias_gen$48
* cell instance $121 r0 *1 17.19,2.44
X$121 VDD vias_gen$48
* cell instance $122 r0 *1 7.43,-6.32
X$122 VDD \$I121 vias_gen$36
* cell instance $123 r0 *1 7.43,-6.61
X$123 VDD \$I121 vias_gen$5
* cell instance $124 r0 *1 21.31,-6.32
X$124 VDD \$I121 vias_gen$36
* cell instance $125 r0 *1 32.61,2.63
X$125 VDD vias_gen$32
* cell instance $126 r0 *1 27.62,2.63
X$126 VDD vias_gen$32
* cell instance $127 r0 *1 42.56,2.63
X$127 VDD vias_gen$32
* cell instance $128 r0 *1 37.63,2.63
X$128 VDD vias_gen$32
* cell instance $129 r0 *1 21.31,-10.33
X$129 \$I5 VSS vias_gen$13
* cell instance $130 r0 *1 7.43,-7.3
X$130 \$I5 VSS vias_gen$8
* cell instance $131 r0 *1 6.38,-7.73
X$131 \$I32 VSS vias_gen$7
* cell instance $132 r0 *1 3.49,1.78
X$132 \$I32 VSS vias_gen$12
* cell instance $133 r0 *1 43.67,-9.42
X$133 \$I85 VSS vias_gen$29
* cell instance $134 r0 *1 43.67,-1.27
X$134 \$I85 VSS vias_gen$3
* cell instance $135 r0 *1 22.61,1.71
X$135 \$I85 VSS vias_gen$6
* cell instance $136 r0 *1 43.68,0.25
X$136 VSS vias_gen$63
* cell instance $137 r0 *1 42.85,0.16
X$137 VSS vias_gen$58
* cell instance $138 r0 *1 37.94,0.16
X$138 VSS vias_gen$58
* cell instance $139 r0 *1 32.95,0.16
X$139 VSS vias_gen$58
* cell instance $140 r0 *1 23.05,0.16
X$140 VSS vias_gen$58
* cell instance $141 r0 *1 27.95,0.16
X$141 VSS vias_gen$58
* cell instance $142 r0 *1 4.3,-6.53
X$142 VSS vias_gen$61
* cell instance $143 r0 *1 4.31,0.04
X$143 VSS vias_gen$60
* cell instance $144 r0 *1 3.49,-7.73
X$144 \$I32 VSS vias_gen$7
* cell instance $145 r0 *1 3.49,-8.02
X$145 \$I32 VSS vias_gen$12
* cell instance $146 r0 *1 12.86,-9.43
X$146 VSS vias_gen$44
* cell instance $147 r0 *1 21.33,-9.43
X$147 VSS vias_gen$44
* cell instance $148 r0 *1 15.86,-9.43
X$148 VSS vias_gen$44
* cell instance $149 r0 *1 18.86,-9.43
X$149 VSS vias_gen$44
* cell instance $150 r0 *1 22.22,-9.43
X$150 VSS vias_gen$44
* cell instance $151 r0 *1 22.2,-9.71
X$151 \$I85 VSS vias_gen$27
* cell instance $152 r0 *1 22.2,-9.42
X$152 \$I85 VSS vias_gen$29
* cell instance $153 r0 *1 22.2,-1.27
X$153 \$I85 VSS vias_gen$3
* cell instance $154 r0 *1 22.61,-1.27
X$154 \$I85 VSS vias_gen$6
* cell instance $155 r0 *1 22.22,0.25
X$155 VSS vias_gen$63
* cell instance $156 r0 *1 9.86,-9.43
X$156 VSS vias_gen$62
* cell instance $157 r0 *1 7.43,-10.33
X$157 \$I5 VSS vias_gen$13
* cell instance $158 r0 *1 7.43,-10.62
X$158 \$I5 VSS vias_gen$8
* cell instance $159 r0 *1 7.45,-9.3
X$159 VSS vias_gen$58
* device instance $1 r0 *1 20.85,-40.02 sky130_fd_pr__model__cap_mim_m4
XC$1 VO_ota \$18 sky130_fd_pr__model__cap_mim_m4 C=4.9952 A=2.4976e+15
+ P=201200000
.ENDS TOP

* cell vias_gen$8
* pin
* pin VSS
.SUBCKT vias_gen$8 \$2 VSS
.ENDS vias_gen$8

* cell vias_gen$5
* pin
* pin
.SUBCKT vias_gen$5 \$1 \$2
.ENDS vias_gen$5

* cell nfet$4
* pin
* pin
* pin
* pin VSS
.SUBCKT nfet$4 \$1 \$2 \$3 VSS
* device instance $1 r0 *1 0.8,4 sky130_fd_pr__nfet_01v8
XM$1 \$1 \$3 \$2 VSS sky130_fd_pr__nfet_01v8 L=1000000 W=8000000 AS=2.4e+12
+ AD=2.4e+12 PS=16600000 PD=16600000
.ENDS nfet$4

* cell vias_gen$12
* pin
* pin VSS
.SUBCKT vias_gen$12 \$2 VSS
.ENDS vias_gen$12

* cell vias_gen$7
* pin
* pin VSS
.SUBCKT vias_gen$7 \$2 VSS
.ENDS vias_gen$7

* cell vias_gen$21
* pin
.SUBCKT vias_gen$21 \$1
.ENDS vias_gen$21

* cell vias_gen$62
* pin
.SUBCKT vias_gen$62 \$1
.ENDS vias_gen$62

* cell vias_gen$61
* pin
.SUBCKT vias_gen$61 \$1
.ENDS vias_gen$61

* cell vias_gen$36
* pin
* pin
.SUBCKT vias_gen$36 \$1 \$2
.ENDS vias_gen$36

* cell vias_gen$13
* pin
* pin VSS
.SUBCKT vias_gen$13 \$2 VSS
.ENDS vias_gen$13

* cell pfet$6
* pin
* pin
* pin
* pin
* pin
* pin
.SUBCKT pfet$6 \$1 \$2 \$3 \$4 \$5 \$6
* device instance $1 r0 *1 0.8,3.125 sky130_fd_pr__pfet_01v8_lvt
XM$1 \$1 \$4 \$2 \$6 sky130_fd_pr__pfet_01v8_lvt L=1000000 W=6250000
+ AS=1.875e+12 AD=1.5625e+12 PS=13100000 PD=6750000
* device instance $2 r0 *1 2.3,3.125 sky130_fd_pr__pfet_01v8_lvt
XM$2 \$2 \$5 \$3 \$6 sky130_fd_pr__pfet_01v8_lvt L=1000000 W=6250000
+ AS=1.5625e+12 AD=1.875e+12 PS=6750000 PD=13100000
.ENDS pfet$6

* cell vias_gen$26
* pin
.SUBCKT vias_gen$26 \$1
.ENDS vias_gen$26

* cell vias_gen$18
* pin
.SUBCKT vias_gen$18 \$1
.ENDS vias_gen$18

* cell nfet
* pin
* pin
* pin
* pin
* pin
* pin
* pin
* pin
* pin
* pin
* pin
* pin
* pin
* pin
* pin
* pin
* pin
* pin VSS
.SUBCKT nfet \$1 \$2 \$3 \$4 \$5 \$6 \$7 \$8 \$9 \$10 \$11 \$12 \$13 \$14 \$15
+ \$16 \$17 VSS
* device instance $1 r0 *1 0.8,0.75 sky130_fd_pr__nfet_01v8
XM$1 \$1 \$10 \$2 VSS sky130_fd_pr__nfet_01v8 L=1000000 W=1500000
+ AS=450000000000 AD=375000000000 PS=3600000 PD=2000000
* device instance $2 r0 *1 2.3,0.75 sky130_fd_pr__nfet_01v8
XM$2 \$2 \$11 \$3 VSS sky130_fd_pr__nfet_01v8 L=1000000 W=1500000
+ AS=375000000000 AD=375000000000 PS=2000000 PD=2000000
* device instance $3 r0 *1 3.8,0.75 sky130_fd_pr__nfet_01v8
XM$3 \$3 \$12 \$4 VSS sky130_fd_pr__nfet_01v8 L=1000000 W=1500000
+ AS=375000000000 AD=375000000000 PS=2000000 PD=2000000
* device instance $4 r0 *1 5.3,0.75 sky130_fd_pr__nfet_01v8
XM$4 \$4 \$13 \$5 VSS sky130_fd_pr__nfet_01v8 L=1000000 W=1500000
+ AS=375000000000 AD=375000000000 PS=2000000 PD=2000000
* device instance $5 r0 *1 6.8,0.75 sky130_fd_pr__nfet_01v8
XM$5 \$5 \$14 \$6 VSS sky130_fd_pr__nfet_01v8 L=1000000 W=1500000
+ AS=375000000000 AD=375000000000 PS=2000000 PD=2000000
* device instance $6 r0 *1 8.3,0.75 sky130_fd_pr__nfet_01v8
XM$6 \$6 \$15 \$7 VSS sky130_fd_pr__nfet_01v8 L=1000000 W=1500000
+ AS=375000000000 AD=375000000000 PS=2000000 PD=2000000
* device instance $7 r0 *1 9.8,0.75 sky130_fd_pr__nfet_01v8
XM$7 \$7 \$16 \$8 VSS sky130_fd_pr__nfet_01v8 L=1000000 W=1500000
+ AS=375000000000 AD=375000000000 PS=2000000 PD=2000000
* device instance $8 r0 *1 11.3,0.75 sky130_fd_pr__nfet_01v8
XM$8 \$8 \$17 \$9 VSS sky130_fd_pr__nfet_01v8 L=1000000 W=1500000
+ AS=375000000000 AD=450000000000 PS=2000000 PD=3600000
.ENDS nfet

* cell vias_gen$60
* pin
.SUBCKT vias_gen$60 \$1
.ENDS vias_gen$60

* cell pfet$4
* pin
* pin
* pin
* pin
* pin
* pin
* pin
* pin
* pin
* pin
* pin
* pin
* pin
* pin
* pin
* pin
* pin
* pin
.SUBCKT pfet$4 \$1 \$2 \$3 \$4 \$5 \$6 \$7 \$8 \$9 \$10 \$11 \$12 \$13 \$14
+ \$15 \$16 \$17 \$18
* device instance $1 r0 *1 0.8,3.25 sky130_fd_pr__pfet_01v8_lvt
XM$1 \$1 \$10 \$2 \$18 sky130_fd_pr__pfet_01v8_lvt L=1000000 W=6500000
+ AS=1.95e+12 AD=1.625e+12 PS=13600000 PD=7000000
* device instance $2 r0 *1 2.3,3.25 sky130_fd_pr__pfet_01v8_lvt
XM$2 \$2 \$11 \$3 \$18 sky130_fd_pr__pfet_01v8_lvt L=1000000 W=6500000
+ AS=1.625e+12 AD=1.625e+12 PS=7000000 PD=7000000
* device instance $3 r0 *1 3.8,3.25 sky130_fd_pr__pfet_01v8_lvt
XM$3 \$3 \$12 \$4 \$18 sky130_fd_pr__pfet_01v8_lvt L=1000000 W=6500000
+ AS=1.625e+12 AD=1.625e+12 PS=7000000 PD=7000000
* device instance $4 r0 *1 5.3,3.25 sky130_fd_pr__pfet_01v8_lvt
XM$4 \$4 \$13 \$5 \$18 sky130_fd_pr__pfet_01v8_lvt L=1000000 W=6500000
+ AS=1.625e+12 AD=1.625e+12 PS=7000000 PD=7000000
* device instance $5 r0 *1 6.8,3.25 sky130_fd_pr__pfet_01v8_lvt
XM$5 \$5 \$14 \$6 \$18 sky130_fd_pr__pfet_01v8_lvt L=1000000 W=6500000
+ AS=1.625e+12 AD=1.625e+12 PS=7000000 PD=7000000
* device instance $6 r0 *1 8.3,3.25 sky130_fd_pr__pfet_01v8_lvt
XM$6 \$6 \$15 \$7 \$18 sky130_fd_pr__pfet_01v8_lvt L=1000000 W=6500000
+ AS=1.625e+12 AD=1.625e+12 PS=7000000 PD=7000000
* device instance $7 r0 *1 9.8,3.25 sky130_fd_pr__pfet_01v8_lvt
XM$7 \$7 \$16 \$8 \$18 sky130_fd_pr__pfet_01v8_lvt L=1000000 W=6500000
+ AS=1.625e+12 AD=1.625e+12 PS=7000000 PD=7000000
* device instance $8 r0 *1 11.3,3.25 sky130_fd_pr__pfet_01v8_lvt
XM$8 \$8 \$17 \$9 \$18 sky130_fd_pr__pfet_01v8_lvt L=1000000 W=6500000
+ AS=1.625e+12 AD=1.95e+12 PS=7000000 PD=13600000
.ENDS pfet$4

* cell vias_gen$14
* pin
.SUBCKT vias_gen$14 \$1
.ENDS vias_gen$14

* cell pfet
* pin
* pin
* pin
* pin
* pin
* pin
* pin
* pin
* pin
* pin
* pin
* pin
* pin
* pin
* pin
* pin
* pin
* pin
.SUBCKT pfet \$1 \$2 \$3 \$4 \$5 \$6 \$7 \$8 \$9 \$10 \$11 \$12 \$13 \$14 \$15
+ \$16 \$17 \$18
* device instance $1 r0 *1 0.8,3.125 sky130_fd_pr__pfet_01v8_lvt
XM$1 \$1 \$10 \$2 \$18 sky130_fd_pr__pfet_01v8_lvt L=1000000 W=6250000
+ AS=2.65625e+12 AD=1.5625e+12 PS=13350000 PD=6750000
* device instance $2 r0 *1 2.3,3.125 sky130_fd_pr__pfet_01v8_lvt
XM$2 \$2 \$11 \$3 \$18 sky130_fd_pr__pfet_01v8_lvt L=1000000 W=6250000
+ AS=1.5625e+12 AD=1.5625e+12 PS=6750000 PD=6750000
* device instance $3 r0 *1 3.8,3.125 sky130_fd_pr__pfet_01v8_lvt
XM$3 \$3 \$12 \$4 \$18 sky130_fd_pr__pfet_01v8_lvt L=1000000 W=6250000
+ AS=1.5625e+12 AD=1.5625e+12 PS=6750000 PD=6750000
* device instance $4 r0 *1 5.3,3.125 sky130_fd_pr__pfet_01v8_lvt
XM$4 \$4 \$13 \$5 \$18 sky130_fd_pr__pfet_01v8_lvt L=1000000 W=6250000
+ AS=1.5625e+12 AD=1.5625e+12 PS=6750000 PD=6750000
* device instance $5 r0 *1 6.8,3.125 sky130_fd_pr__pfet_01v8_lvt
XM$5 \$5 \$14 \$6 \$18 sky130_fd_pr__pfet_01v8_lvt L=1000000 W=6250000
+ AS=1.5625e+12 AD=1.5625e+12 PS=6750000 PD=6750000
* device instance $6 r0 *1 8.3,3.125 sky130_fd_pr__pfet_01v8_lvt
XM$6 \$6 \$15 \$7 \$18 sky130_fd_pr__pfet_01v8_lvt L=1000000 W=6250000
+ AS=1.5625e+12 AD=1.5625e+12 PS=6750000 PD=6750000
* device instance $7 r0 *1 9.8,3.125 sky130_fd_pr__pfet_01v8_lvt
XM$7 \$7 \$16 \$8 \$18 sky130_fd_pr__pfet_01v8_lvt L=1000000 W=6250000
+ AS=1.5625e+12 AD=1.5625e+12 PS=6750000 PD=6750000
* device instance $8 r0 *1 11.3,3.125 sky130_fd_pr__pfet_01v8_lvt
XM$8 \$8 \$17 \$9 \$18 sky130_fd_pr__pfet_01v8_lvt L=1000000 W=6250000
+ AS=1.5625e+12 AD=2.65625e+12 PS=6750000 PD=13350000
.ENDS pfet

* cell vias_gen$50
* pin
.SUBCKT vias_gen$50 \$1
.ENDS vias_gen$50

* cell vias_gen$32
* pin
.SUBCKT vias_gen$32 \$1
.ENDS vias_gen$32

* cell nfet$3
* pin
* pin
* pin
* pin
* pin
* pin
* pin
* pin
* pin
* pin
* pin
* pin
* pin
* pin
* pin
* pin
* pin
* pin VSS
.SUBCKT nfet$3 \$1 \$2 \$3 \$4 \$5 \$6 \$7 \$8 \$9 \$10 \$11 \$12 \$13 \$14
+ \$15 \$16 \$17 VSS
* device instance $1 r0 *1 1.3,0.5 sky130_fd_pr__nfet_01v8
XM$1 \$1 \$10 \$2 VSS sky130_fd_pr__nfet_01v8 L=2000000 W=1000000
+ AS=300000000000 AD=250000000000 PS=2600000 PD=1500000
* device instance $2 r0 *1 3.8,0.5 sky130_fd_pr__nfet_01v8
XM$2 \$2 \$11 \$3 VSS sky130_fd_pr__nfet_01v8 L=2000000 W=1000000
+ AS=250000000000 AD=250000000000 PS=1500000 PD=1500000
* device instance $3 r0 *1 6.3,0.5 sky130_fd_pr__nfet_01v8
XM$3 \$3 \$12 \$4 VSS sky130_fd_pr__nfet_01v8 L=2000000 W=1000000
+ AS=250000000000 AD=250000000000 PS=1500000 PD=1500000
* device instance $4 r0 *1 8.8,0.5 sky130_fd_pr__nfet_01v8
XM$4 \$4 \$13 \$5 VSS sky130_fd_pr__nfet_01v8 L=2000000 W=1000000
+ AS=250000000000 AD=250000000000 PS=1500000 PD=1500000
* device instance $5 r0 *1 11.3,0.5 sky130_fd_pr__nfet_01v8
XM$5 \$5 \$14 \$6 VSS sky130_fd_pr__nfet_01v8 L=2000000 W=1000000
+ AS=250000000000 AD=250000000000 PS=1500000 PD=1500000
* device instance $6 r0 *1 13.8,0.5 sky130_fd_pr__nfet_01v8
XM$6 \$6 \$15 \$7 VSS sky130_fd_pr__nfet_01v8 L=2000000 W=1000000
+ AS=250000000000 AD=250000000000 PS=1500000 PD=1500000
* device instance $7 r0 *1 16.3,0.5 sky130_fd_pr__nfet_01v8
XM$7 \$7 \$16 \$8 VSS sky130_fd_pr__nfet_01v8 L=2000000 W=1000000
+ AS=250000000000 AD=250000000000 PS=1500000 PD=1500000
* device instance $8 r0 *1 18.8,0.5 sky130_fd_pr__nfet_01v8
XM$8 \$8 \$17 \$9 VSS sky130_fd_pr__nfet_01v8 L=2000000 W=1000000
+ AS=250000000000 AD=300000000000 PS=1500000 PD=2600000
.ENDS nfet$3

* cell vias_gen$56
* pin
.SUBCKT vias_gen$56 \$1
.ENDS vias_gen$56

* cell vias_gen$48
* pin
.SUBCKT vias_gen$48 \$1
.ENDS vias_gen$48

* cell vias_gen$58
* pin
.SUBCKT vias_gen$58 \$1
.ENDS vias_gen$58

* cell vias_gen$6
* pin
* pin VSS
.SUBCKT vias_gen$6 \$2 VSS
.ENDS vias_gen$6

* cell vias_gen
* pin
* pin
.SUBCKT vias_gen \$1 \$2
.ENDS vias_gen

* cell vias_gen$46
* pin
.SUBCKT vias_gen$46 \$1
.ENDS vias_gen$46

* cell pfet$2
* pin
* pin
* pin
* pin
* pin
* pin
* pin
* pin
* pin
* pin
* pin
* pin
* pin
* pin
* pin
* pin
* pin
* pin
.SUBCKT pfet$2 \$1 \$2 \$3 \$4 \$5 \$6 \$7 \$8 \$9 \$10 \$11 \$12 \$13 \$14
+ \$15 \$16 \$17 \$18
* device instance $1 r0 *1 1.3,3.125 sky130_fd_pr__pfet_01v8_lvt
XM$1 \$1 \$10 \$2 \$18 sky130_fd_pr__pfet_01v8_lvt L=2000000 W=6250000
+ AS=1.875e+12 AD=1.5625e+12 PS=13100000 PD=6750000
* device instance $2 r0 *1 3.8,3.125 sky130_fd_pr__pfet_01v8_lvt
XM$2 \$2 \$11 \$3 \$18 sky130_fd_pr__pfet_01v8_lvt L=2000000 W=6250000
+ AS=1.5625e+12 AD=1.5625e+12 PS=6750000 PD=6750000
* device instance $3 r0 *1 6.3,3.125 sky130_fd_pr__pfet_01v8_lvt
XM$3 \$3 \$12 \$4 \$18 sky130_fd_pr__pfet_01v8_lvt L=2000000 W=6250000
+ AS=1.5625e+12 AD=1.5625e+12 PS=6750000 PD=6750000
* device instance $4 r0 *1 8.8,3.125 sky130_fd_pr__pfet_01v8_lvt
XM$4 \$4 \$13 \$5 \$18 sky130_fd_pr__pfet_01v8_lvt L=2000000 W=6250000
+ AS=1.5625e+12 AD=1.5625e+12 PS=6750000 PD=6750000
* device instance $5 r0 *1 11.3,3.125 sky130_fd_pr__pfet_01v8_lvt
XM$5 \$5 \$14 \$6 \$18 sky130_fd_pr__pfet_01v8_lvt L=2000000 W=6250000
+ AS=1.5625e+12 AD=1.5625e+12 PS=6750000 PD=6750000
* device instance $6 r0 *1 13.8,3.125 sky130_fd_pr__pfet_01v8_lvt
XM$6 \$6 \$15 \$7 \$18 sky130_fd_pr__pfet_01v8_lvt L=2000000 W=6250000
+ AS=1.5625e+12 AD=1.5625e+12 PS=6750000 PD=6750000
* device instance $7 r0 *1 16.3,3.125 sky130_fd_pr__pfet_01v8_lvt
XM$7 \$7 \$16 \$8 \$18 sky130_fd_pr__pfet_01v8_lvt L=2000000 W=6250000
+ AS=1.5625e+12 AD=1.5625e+12 PS=6750000 PD=6750000
* device instance $8 r0 *1 18.8,3.125 sky130_fd_pr__pfet_01v8_lvt
XM$8 \$8 \$17 \$9 \$18 sky130_fd_pr__pfet_01v8_lvt L=2000000 W=6250000
+ AS=1.5625e+12 AD=1.875e+12 PS=6750000 PD=13100000
.ENDS pfet$2

* cell vias_gen$34
* pin
.SUBCKT vias_gen$34 \$1
.ENDS vias_gen$34

* cell vias_gen$51
* pin
.SUBCKT vias_gen$51 \$1
.ENDS vias_gen$51

* cell vias_gen$24
* pin
.SUBCKT vias_gen$24 \$1
.ENDS vias_gen$24

* cell vias_gen$22
* pin
.SUBCKT vias_gen$22 \$1
.ENDS vias_gen$22

* cell vias_gen$20
* pin
.SUBCKT vias_gen$20 \$1
.ENDS vias_gen$20

* cell vias_gen$16
* pin
.SUBCKT vias_gen$16 \$1
.ENDS vias_gen$16

* cell res_poly
* pin
* pin
* pin VSS
.SUBCKT res_poly \$1 \$2 VSS
* device instance $1 r0 *1 0,0 sky130_fd_pr__res_xhigh_po_0p35
XR$1 \$2 \$1 VSS sky130_fd_pr__res_xhigh_po_0p35 R=86400 L=15120000 W=350000
+ A=5.292e+12 P=30940000
.ENDS res_poly

* cell vias_gen$63
* pin
.SUBCKT vias_gen$63 \$1
.ENDS vias_gen$63

* cell vias_gen$44
* pin
.SUBCKT vias_gen$44 \$1
.ENDS vias_gen$44

* cell mim_cap
* pin
* pin
.SUBCKT mim_cap \$1 \$2
.ENDS mim_cap

* cell vias_gen$27
* pin
* pin VSS
.SUBCKT vias_gen$27 \$2 VSS
.ENDS vias_gen$27

* cell vias_gen$29
* pin
* pin VSS
.SUBCKT vias_gen$29 \$2 VSS
.ENDS vias_gen$29

* cell vias_gen$3
* pin
* pin VSS
.SUBCKT vias_gen$3 \$2 VSS
.ENDS vias_gen$3

* cell vias_gen$4
* pin
* pin
.SUBCKT vias_gen$4 \$1 \$2
.ENDS vias_gen$4
