* Extracted by KLayout with SKY130 LVS runset on : 20/10/2026 02:58

* cell LDO
* pin VDD
* pin VOUT
* pin VIN
* pin Vre
* pin VSS
.SUBCKT LDO VDD VOUT VIN Vre VSS
* cell instance $2 r0 *1 -2.12,16.79
X$2 \$27 \$18 Vre \$19 VDD VSS OTA
* cell instance $10 r0 *1 -31.16,13.18
X$10 \$18 VDD VSS self_bias
* device instance $1 r0 *1 62.14,-12.24 sky130_fd_pr__model__cap_mim_m4
XC$1 VOUT \$19 sky130_fd_pr__model__cap_mim_m4 C=2.1 A=1.05e+15 P=130000000
* device instance $2 r270 *1 49.74,27.59 sky130_fd_pr__res_xhigh_po_0p69
XR$2 VSS VOUT VSS sky130_fd_pr__res_xhigh_po_0p69 R=11942.0289855 L=4120000
+ W=690000 A=2.8428e+12 P=9620000
* device instance $3 r270 *1 55.49,20.2 sky130_fd_pr__res_xhigh_po_0p69
XR$3 VOUT \$19 VSS sky130_fd_pr__res_xhigh_po_0p69 R=110376.811594 L=38080000
+ W=690000 A=2.62752e+13 P=81680000
* device instance $5 r270 *1 55.48,12.34 sky130_fd_pr__res_xhigh_po_0p69
XR$5 \$19 VSS VSS sky130_fd_pr__res_xhigh_po_0p69 R=110376.811594 L=38080000
+ W=690000 A=2.62752e+13 P=81680000
* device instance $11 m0 *1 -29.75,35.76 sky130_fd_pr__pfet_01v8_lvt
XM$11 VOUT \$27 VIN VDD sky130_fd_pr__pfet_01v8_lvt L=500000 W=750000000
+ AS=1.88e+14 AD=1.88e+14 PS=797600000 PD=797600000
.ENDS LDO

* cell self_bias
* pin VR
* pin VDD
* pin VSS
.SUBCKT self_bias VR VDD VSS
* device instance $1 r0 *1 4.65,12.665 sky130_fd_pr__pfet_01v8_lvt
XM$1 VDD VR vp4 VDD sky130_fd_pr__pfet_01v8_lvt L=5000000 W=500000
+ AS=150000000000 AD=150000000000 PS=1600000 PD=1600000
* device instance $2 r0 *1 4.65,11.765 sky130_fd_pr__pfet_01v8_lvt
XM$2 vp3 VR vp4 VDD sky130_fd_pr__pfet_01v8_lvt L=5000000 W=500000
+ AS=150000000000 AD=150000000000 PS=1600000 PD=1600000
* device instance $3 r0 *1 4.65,10.865 sky130_fd_pr__pfet_01v8_lvt
XM$3 vp3 VR vp2 VDD sky130_fd_pr__pfet_01v8_lvt L=5000000 W=500000
+ AS=150000000000 AD=150000000000 PS=1600000 PD=1600000
* device instance $4 r0 *1 4.65,9.965 sky130_fd_pr__pfet_01v8_lvt
XM$4 vp1 VR vp2 VDD sky130_fd_pr__pfet_01v8_lvt L=5000000 W=500000
+ AS=150000000000 AD=150000000000 PS=1600000 PD=1600000
* device instance $5 r0 *1 4.65,9.085 sky130_fd_pr__pfet_01v8_lvt
XM$5 vp1 VR vdinv VDD sky130_fd_pr__pfet_01v8_lvt L=5000000 W=500000
+ AS=150000000000 AD=150000000000 PS=1600000 PD=1600000
* device instance $6 r0 *1 1.96,3.62 sky130_fd_pr__nfet_01v8
XM$6 VSS VR vdinv VSS sky130_fd_pr__nfet_01v8 L=1000000 W=20000000 AS=5.2e+12
+ AD=5.2e+12 PS=26600000 PD=26600000
* device instance $11 r270 *1 14.02,-0.3 sky130_fd_pr__res_xhigh_po_0p69
XR$11 VSS VR VSS sky130_fd_pr__res_xhigh_po_0p69 R=60000 L=20700000 W=690000
+ A=1.4283e+13 P=42780000
* device instance $12 m0 *1 12.32,2.48 sky130_fd_pr__nfet_01v8
XM$12 VSS vdinv vgp_self VSS sky130_fd_pr__nfet_01v8 L=1000000 W=2000000
+ AS=550000000000 AD=550000000000 PS=4100000 PD=4100000
* device instance $14 m0 *1 19.57,4.01 sky130_fd_pr__nfet_01v8
XM$14 VR vdi vgp_self VSS sky130_fd_pr__nfet_01v8 L=1000000 W=24000000
+ AS=6.2e+12 AD=6.2e+12 PS=31100000 PD=31100000
* device instance $20 r0 *1 10.66,5.11 sky130_fd_pr__nfet_01v8
XM$20 VSS VR vdi VSS sky130_fd_pr__nfet_01v8 L=1000000 W=5000000 AS=1.3e+12
+ AD=1.3e+12 PS=8600000 PD=8600000
* device instance $25 r0 *1 10.56,10.49 sky130_fd_pr__pfet_01v8_lvt
XM$25 VDD vgp_self vdi VDD sky130_fd_pr__pfet_01v8_lvt L=1000000 W=30000000
+ AS=7.75e+12 AD=7.5e+12 PS=38100000 PD=33000000
* device instance $31 r0 *1 19.56,10.49 sky130_fd_pr__pfet_01v8_lvt
XM$31 VDD vgp_self vgp_self VDD sky130_fd_pr__pfet_01v8_lvt L=1000000
+ W=30000000 AS=7.5e+12 AD=7.75e+12 PS=33000000 PD=38100000
.ENDS self_bias

* cell OTA
* pin VO_ota
* pin VGN
* pin VIN_ota
* pin VIP_ota
* pin VDD
* pin VSS
.SUBCKT OTA VO_ota VGN VIN_ota VIP_ota VDD VSS
* device instance $1 r0 *1 7.69,-28.91 sky130_fd_pr__model__cap_mim_m4
XC$1 VO_ota vmiler sky130_fd_pr__model__cap_mim_m4 C=4.9952 A=2.4976e+15
+ P=212720000
* device instance $2 r0 *1 5.04,6.675 sky130_fd_pr__pfet_01v8_lvt
XM$2 VDD vgp vgp VDD sky130_fd_pr__pfet_01v8_lvt L=1000000 W=12500000
+ AS=3.4375e+12 AD=3.4375e+12 PS=19850000 PD=19850000
* device instance $4 m0 *1 5.14,-2.53 sky130_fd_pr__nfet_01v8
XM$4 VSS VGN vgp VSS sky130_fd_pr__nfet_01v8 L=1000000 W=8000000 AS=2.4e+12
+ AD=2.4e+12 PS=16600000 PD=16600000
* device instance $5 m0 *1 24.39,0.51 sky130_fd_pr__nfet_01v8
XM$5 VSS vo1 VO_ota VSS sky130_fd_pr__nfet_01v8 L=2000000 W=8000000 AS=2.05e+12
+ AD=2.05e+12 PS=13100000 PD=13100000
* device instance $13 r0 *1 24.39,6.705 sky130_fd_pr__pfet_01v8_lvt
XM$13 VDD vgp VO_ota VDD sky130_fd_pr__pfet_01v8_lvt L=2000000 W=50000000
+ AS=1.28125e+13 AD=1.28125e+13 PS=60350000 PD=60350000
* device instance $23 r90 *1 32.98,-2.06 sky130_fd_pr__res_xhigh_po_0p35
XR$23 vmiler vo1 VSS sky130_fd_pr__res_xhigh_po_0p35 R=518400 L=90720000
+ W=350000 A=3.1752e+13 P=185640000
* device instance $27 m0 *1 9.3,-8.68 sky130_fd_pr__nfet_01v8
XM$27 mnr|vd mnr|vd VSS VSS sky130_fd_pr__nfet_01v8 L=1000000 W=6000000
+ AS=1.575e+12 AD=1.575e+12 PS=9600000 PD=9600000
* device instance $28 m0 *1 10.8,-8.68 sky130_fd_pr__nfet_01v8
XM$28 VSS mnr|vd vo1 VSS sky130_fd_pr__nfet_01v8 L=1000000 W=6000000 AS=1.5e+12
+ AD=1.5e+12 PS=8000000 PD=8000000
* device instance $35 m0 *1 9.31,-1.67 sky130_fd_pr__pfet_01v8_lvt
XM$35 mnr|vd VIN_ota vtail VDD sky130_fd_pr__pfet_01v8_lvt L=1000000 W=26000000
+ AS=6.825e+12 AD=6.825e+12 PS=34600000 PD=34600000
* device instance $36 m0 *1 10.81,-1.67 sky130_fd_pr__pfet_01v8_lvt
XM$36 vtail VIP_ota vo1 VDD sky130_fd_pr__pfet_01v8_lvt L=1000000 W=26000000
+ AS=6.5e+12 AD=6.5e+12 PS=28000000 PD=28000000
* device instance $43 r0 *1 9.31,6.705 sky130_fd_pr__pfet_01v8_lvt
XM$43 VDD vgp vtail VDD sky130_fd_pr__pfet_01v8_lvt L=1000000 W=50000000
+ AS=1.359375e+13 AD=1.359375e+13 PS=60600000 PD=60600000
.ENDS OTA
