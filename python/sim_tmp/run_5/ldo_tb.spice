** sch_path: /foss/designs/LDO-sky130/xschem/ldo_tb.sch
**.subckt ldo_tb
x1 vi vo net2 net1 0 LDO
V1 net2 0 {VDD}
V2 net1 0 {VREF} ac 1
V3 vi 0 {VIN}
R1 vo 0 {RL}
C1 vo 0 {CL}
**** begin user architecture code

* 1. Inclusión de libreria de modelos Sky130 PRIMERO
.lib /foss/pdks/sky130A/libs.tech/ngspice/sky130.lib.spice tt

**parametros_ldo
.param VDD = 1.8
.param VREF = 0.6
.param VIN = 1.8
.param RL = 100
.param CL = 1u
.param tsim = 2m

* Definición de análisis transitorio
.tran 1u {tsim}

.control
set filetype=ascii

* 1. Punto de Operación (.OP)
op
write LDO_op.raw

* 2. Análisis Transitorio (.TRAN)
run
write LDO_trans.raw

* 3. Análisis en Frecuencia (.AC)
ac dec 10 1 1G
write LDO_ac.raw

* 4. Frecuencia de Corte a -3dB
let target_3db = vdb(vo)[0] - 3.0
meas ac f3db WHEN vdb(vo) = target_3db

* 5. UGB (Frecuencia donde la magnitud cruza 0 dB)
meas ac ugb WHEN vdb(vo) = 0.0

* 6. Crear el vector de fase en grados (vp * 180 / pi)
let fase_deg = vp(vo) * 180 / pi

* 7. Medir la fase en grados en el punto exacto del UGB y calcular Margen de Fase
meas ac fase_ugb FIND fase_deg WHEN vdb(vo) = 0.0
let margen_fase = 180 + fase_ugb

* 8. Imprimir resultados en consola
print f3db ugb fase_ugb margen_fase

* 9. Graficar la magnitud en dB y la fase en grados
plot vdb(vo)
plot fase_deg
.endc

**** end user architecture code
**.ends

* expanding   symbol:  /foss/designs/LDO-sky130/xschem/LDO.sym # of pins=5
** sym_path: /foss/designs/LDO-sky130/xschem/LDO.sym
** sch_path: /foss/designs/LDO-sky130/xschem/LDO.sch
.subckt LDO VIN VOUT VDD Vref VSS
*.ipin VIN
*.iopin VDD
*.opin VOUT
*.ipin Vref
*.iopin VSS
x1 VDD net2 Vref net3 net1 VSS OTA
I0 VDD net1 10u
XM1 VOUT net2 VIN VDD sky130_fd_pr__pfet_01v8_lvt L=0.35 W=1000 nf=50 ad=145 as=150.8 pd=1014.5 ps=1055.08 nrd=0.00029 nrs=0.00029
+ sa=0 sb=0 sd=0 mult=5 m=5
XR1 Vre VOUT VDD sky130_fd_pr__res_iso_pw W=2.65 L=2.65
XR2 VSS Vre VDD sky130_fd_pr__res_iso_pw W=2.65 L=2.65
L4 Vre net3 1T
.ends

* expanding   symbol:  /foss/designs/LDO-sky130/xschem/OTA.sym # of pins=6
** sym_path: /foss/designs/LDO-sky130/xschem/OTA.sym
** sch_path: /foss/designs/LDO-sky130/xschem/OTA.sch
.subckt OTA VDD VO_ota VIN_ota VIP_ota Iref VSS
*.ipin VIN_ota
*.opin VO_ota
*.iopin Iref
*.iopin VSS
*.iopin VDD
*.ipin VIP_ota
XMr Iref Iref VSS VSS sky130_fd_pr__nfet_01v8 L=0.5 W=0.5 nf=1 ad=0.145 as=0.145 pd=1.58 ps=1.58 nrd=0.58 nrs=0.58 sa=0 sb=0 sd=0
+ mult=1
XMo VO_ota VO_ota1 VDD VDD sky130_fd_pr__pfet_01v8 L=0.5 W=20 nf=1 ad=5.8 as=5.8 pd=40.58 ps=40.58 nrd=0.0145 nrs=0.0145 sa=0 sb=0
+ sd=0 mult=1
XMrc1 Vtail Iref VSS VSS sky130_fd_pr__nfet_01v8 L=0.5 W=2 nf=1 ad=0.58 as=0.58 pd=4.58 ps=4.58 nrd=0.145 nrs=0.145 sa=0 sb=0 sd=0
+ mult=1
XMc2 VO_ota Iref VSS VSS sky130_fd_pr__nfet_01v8 L=0.5 W=1 nf=1 ad=0.29 as=0.29 pd=2.58 ps=2.58 nrd=0.29 nrs=0.29 sa=0 sb=0 sd=0
+ mult=1
XMn VGP VIN_ota Vtail VSS sky130_fd_pr__nfet_01v8 L=0.5 W=40 nf=1 ad=11.6 as=11.6 pd=80.58 ps=80.58 nrd=0.00725 nrs=0.00725 sa=0
+ sb=0 sd=0 mult=1
XMp VO_ota1 VIP_ota Vtail VSS sky130_fd_pr__nfet_01v8 L=0.5 W=40 nf=1 ad=11.6 as=11.6 pd=80.58 ps=80.58 nrd=0.00725 nrs=0.00725
+ sa=0 sb=0 sd=0 mult=1
XMpr VO_ota1 VGP VDD VDD sky130_fd_pr__pfet_01v8 L=0.5 W=40 nf=1 ad=11.6 as=11.6 pd=80.58 ps=80.58 nrd=0.00725 nrs=0.00725 sa=0
+ sb=0 sd=0 mult=1
XMnr VGP VGP VDD VDD sky130_fd_pr__pfet_01v8 L=0.5 W=40 nf=1 ad=11.6 as=11.6 pd=80.58 ps=80.58 nrd=0.00725 nrs=0.00725 sa=0 sb=0
+ sd=0 mult=1
XR1 VO_ota1 net1 VDD sky130_fd_pr__res_high_po W=0.4 L=300 mult=1
XC1 VO_ota net1 sky130_fd_pr__cap_mim_m3_2 W=35 L=35 MF=1
.ends

.end
