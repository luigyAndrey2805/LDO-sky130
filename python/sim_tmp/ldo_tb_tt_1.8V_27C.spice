** sch_path: /foss/designs/LDO-sky130/xschem/ldo_tb.sch
**.subckt ldo_tb
x1 vi vo VDD vref 0 LDO
Vsuply VDD 0 dc {VDD} ac {ac_vdd}
Vref vref 0 {VREF}
Vin vi 0 {VIN}
R1 vo 0 {RL}
C1 vo 0 {CL}
Iload vo net1 dc 0 ac 0 PULSE({iload_min} {iload_max} {tstart} {trise} {tfall} {twidth} {tperiod})
Vsense 0 net1 0
**** begin user architecture code

* 1. Inclusión de libreria de modelos Sky130 PRIMERO
.lib /foss/pdks/sky130A/libs.tech/ngspice/sky130.lib.spice tt
.option temp=27

**parametros_ldo
.param VDD = 1.8
.param VREF = 0.6
.param VIN = 1.8
.param RL = 25
.param CL = 1u
.param tsim = 2m
* Parámetros para la prueba de carga del LDO
.param iload_min = 1m
.param iload_max = 50m
.param tstart   = 10u
.param trise    = 100n
.param tfall    = 100n
.param twidth   = 200u
.param tperiod  = 400u
.param tperiod  = 400u
.param tsim = '5*tperiod'

.param ac_iprobe = 1
.param ac_vdd = 0

.control
let tperiod  = 400u
let tsim = '5*tperiod'

set filetype=ascii

* 1. Punto de Operación (.OP)
op
write LDO_op.raw

* 2. Análisis Transitorio para overshot y undershot (.TRAN)
tran 1u $&tsim
write LDO_tran_picos.raw

* 3. Análisis en Frecuencia  para estabilidad (.AC)
ac dec 10 1 1G
* 1. Ganancia de Lazo Abierto T(s) = v(x1.vre) / v(x1.net3)
let T_loop = v(x1.vre) / v(x1.net3)
let loop_gain_db = vdb(T_loop)
let fase_deg = vp(T_loop) * 180 / pi
write LDO_ac_estability.raw

* 4. Análisis en dc sweep para el load regulation
dc iload 100u 50m 100u
*plot vo
*plot vsense#branch
write LDO_dc_load.raw

* 5. Analisis en dc sweep para el line regulation
dc vin 1.3 2 0.01
*plot vo
*plot vi
write LDO_dc_line.raw

*6. análisis en Frecuencia (.AC) para el PSRR
alterparam ac_iprobe = 0
alterparam ac_vdd = 1
reset

ac dec 10 1 1G
* 1. Ganancia de Lazo Abierto T(s) = v(x1.vre) / v(x1.net3)
let psrr1 = v(vdd)/v(vo)
let psrr_db = vdb(psrr1)

write LDO_ac_psrr.raw

*CALCULOS PARA ESTABILIDAD Y GANANCIA EN LAZO ABIERTO

setplot ac1
* 2. UGB (Frecuencia donde la magnitud cruza 0 dB)
meas ac ugb WHEN loop_gain_db = 0.0
* 3. Medir la fase en grados en el punto exacto del UGB
meas ac fase_ugb FIND fase_deg WHEN loop_gain_db = 0.0

* 4. Calcular el Margen de Fase (PM = fase_ugb)
let margen_fase = fase_ugb
meas ac ganancia_banda_plana   find loop_gain_db at=1
echo 'margen_fase = $&fase_ugb'

*CALCULOS PARA EL PSRR
setplot ac2
meas ac gananciaPSRR_1   find psrr_db at=1
meas ac gananciaPSRR_1k  find psrr_db at=1k
meas ac gananciaPSRR_10k find psrr_db at=10k
meas ac gananciaPSRR_1M  find psrr_db at=1Meg

*CALCULOS PARA EL LOAD REGULATION
setplot dc1
meas dc voload_max MAX v(vo)
meas dc voload_min MIN v(vo)
let load_regulation = voload_max - voload_min
echo 'load_regulation = $&load_regulation'

*CALCULOS PARA EL LINE REGULATION
setplot dc2
meas dc voline_max MAX v(vo)
meas dc voline_min MIN v(vo)
let line_regulation = voline_max - voline_min
echo 'line_regulation = $&line_regulation'

.endc

**** end user architecture code
**.ends

* expanding   symbol:  LDO.sym # of pins=5
** sym_path: /foss/designs/LDO-sky130/xschem/LDO.sym
** sch_path: /foss/designs/LDO-sky130/xschem/LDO.sch
.subckt LDO VIN VOUT VDD Vref VSS
*.ipin VIN
*.iopin VDD
*.opin VOUT
*.ipin Vref
*.iopin VSS
x1 VDD net2 Vref net3 net1 VSS OTA
I0 VDD net1 10u
XM1 VOUT net2 VIN VDD sky130_fd_pr__pfet_01v8_lvt L=0.35 W=1000 nf=50 ad=145 as=150.8 pd=1014.5 ps=1055.08 nrd=0.00029 nrs=0.00029
+ sa=0 sb=0 sd=0 mult=5 m=5
XR1 Vre VOUT VDD sky130_fd_pr__res_iso_pw W=0.35 L=10
XR2 VSS Vre VDD sky130_fd_pr__res_iso_pw W=0.35 L=10
V1 net3 Vre 0 ac {ac_iprobe}
XC1 VOUT Vre sky130_fd_pr__cap_mim_m3_2 W=19.5 L=19.5 MF=1
.ends

* expanding   symbol:  OTA.sym # of pins=6
** sym_path: /foss/designs/LDO-sky130/xschem/OTA.sym
** sch_path: /foss/designs/LDO-sky130/xschem/OTA.sch
.subckt OTA VDD VO_ota VIN_ota VIP_ota Iref VSS
*.ipin VIN_ota
*.opin VO_ota
*.iopin Iref
*.iopin VSS
*.iopin VDD
*.ipin VIP_ota
XMr Iref Iref VSS VSS sky130_fd_pr__nfet_01v8 L=0.5 W=0.5 nf=1 ad=0.145 as=0.145 pd=1.58 ps=1.58 nrd=0.58 nrs=0.58 sa=0 sb=0 sd=0
+ mult=1
XMo VO_ota VO_ota1 VDD VDD sky130_fd_pr__pfet_01v8 L=0.5 W=20 nf=1 ad=5.8 as=5.8 pd=40.58 ps=40.58 nrd=0.0145 nrs=0.0145 sa=0 sb=0
+ sd=0 mult=1
XMrc1 Vtail Iref VSS VSS sky130_fd_pr__nfet_01v8 L=0.5 W=2 nf=1 ad=0.58 as=0.58 pd=4.58 ps=4.58 nrd=0.145 nrs=0.145 sa=0 sb=0 sd=0
+ mult=1
XMc2 VO_ota Iref VSS VSS sky130_fd_pr__nfet_01v8 L=0.5 W=1 nf=1 ad=0.29 as=0.29 pd=2.58 ps=2.58 nrd=0.29 nrs=0.29 sa=0 sb=0 sd=0
+ mult=1
XMn VGP VIN_ota Vtail VSS sky130_fd_pr__nfet_01v8 L=0.5 W=40 nf=1 ad=11.6 as=11.6 pd=80.58 ps=80.58 nrd=0.00725 nrs=0.00725 sa=0
+ sb=0 sd=0 mult=1
XMp VO_ota1 VIP_ota Vtail VSS sky130_fd_pr__nfet_01v8 L=0.5 W=40 nf=1 ad=11.6 as=11.6 pd=80.58 ps=80.58 nrd=0.00725 nrs=0.00725
+ sa=0 sb=0 sd=0 mult=1
XMpr VO_ota1 VGP VDD VDD sky130_fd_pr__pfet_01v8 L=0.5 W=40 nf=1 ad=11.6 as=11.6 pd=80.58 ps=80.58 nrd=0.00725 nrs=0.00725 sa=0
+ sb=0 sd=0 mult=1
XMnr VGP VGP VDD VDD sky130_fd_pr__pfet_01v8 L=0.5 W=40 nf=1 ad=11.6 as=11.6 pd=80.58 ps=80.58 nrd=0.00725 nrs=0.00725 sa=0 sb=0
+ sd=0 mult=1
XR1 VO_ota1 net1 VDD sky130_fd_pr__res_high_po W=0.35 L=360 mult=1
XC1 VO_ota net1 sky130_fd_pr__cap_mim_m3_2 W=50 L=50 MF=1
.ends

.end
